* Auto-generated inverter PEX test: tran
.option INGOLD=2 POST=2
.hdl "../../../INPUT_MODEL/inv_test_fet_n.va"
.hdl "../../../INPUT_MODEL/inv_test_fet_p.va"
.include "../../inv_test_pex.inc"
.param VDD_VAL=0.7 VSS_VAL=0
.param VCORE='VDD_VAL-VSS_VAL'
.param CLOAD=5f TRISE=20p TFALL=20p TDELAY=500p PULSE_WIDTH=1n PERIOD=2n TSTEP=1p TSTOP=4n DC_STEP=1m LOGIC_LOW_MAX=0.2 LOGIC_HIGH_MIN=0.8
VVSS VSS 0 'VSS_VAL'
VVDD VDD VSS 'VCORE'

VA A VSS PULSE(0 'VCORE' 'TDELAY' 'TRISE' 'TFALL' 'PULSE_WIDTH' 'PERIOD')
CLOAD Y VSS 'CLOAD'
XDUT A Y VDD VSS INV_TEST_PEX
.tran 'TSTEP' 'TSTOP'
.measure tran TPHL TRIG V(A) VAL='VSS_VAL+0.5*VCORE' RISE=1 TARG V(Y) VAL='VSS_VAL+0.5*VCORE' FALL=1
.measure tran TPLH TRIG V(A) VAL='VSS_VAL+0.5*VCORE' FALL=1 TARG V(Y) VAL='VSS_VAL+0.5*VCORE' RISE=1
.measure tran TR_OUT TRIG V(Y) VAL='VSS_VAL+0.1*VCORE' RISE=1 TARG V(Y) VAL='VSS_VAL+0.9*VCORE' RISE=1
.measure tran TF_OUT TRIG V(Y) VAL='VSS_VAL+0.9*VCORE' FALL=1 TARG V(Y) VAL='VSS_VAL+0.1*VCORE' FALL=1
.print tran V(A) V(Y) I(VVDD)
.end
