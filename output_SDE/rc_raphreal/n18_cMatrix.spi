* SPICE Models for Entire
* Capacitance Matrix (F)
C_0_1                      region_16  region_17    5.6711e-17
C_0_2                      region_16  region_18    4.0638e-17
C_0_3                      region_16  region_19    2.1001e-17
C_0_4                      region_16  region_20    2.6457e-17
C_0_5                      region_16  region_21    2.1058e-17
C_0_6                      region_16  region_22    3.3343e-18
C_1_2                      region_17  region_18    9.3747e-17
C_1_3                      region_17  region_19    2.2228e-19
C_1_4                      region_17  region_20    1.9001e-17
C_1_5                      region_17  region_21    1.5749e-18
C_1_6                      region_17  region_22    1.0008e-17
C_2_3                      region_18  region_19    1.4841e-18
C_2_4                      region_18  region_20    1.8814e-17
C_2_5                      region_18  region_21    3.5742e-19
C_2_6                      region_18  region_22    1.0015e-17
C_3_4                      region_19  region_20    1.1770e-18
C_3_5                      region_19  region_21    2.8132e-20
C_3_6                      region_19  region_22    6.1787e-22
C_4_5                      region_20  region_21    1.0854e-18
C_4_6                      region_20  region_22    1.5293e-21
C_5_6                      region_21  region_22    6.0677e-22
