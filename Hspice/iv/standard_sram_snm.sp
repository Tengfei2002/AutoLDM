***********************************************************************
* Standard 6T SRAM test deck with RC values mapped from schematic names.
* Generated by Hspice/iv/generate_sram_mapped_rc.py.
*
* R source: output_SDE/rc_raphreal/n19_cMatrix.spi
* C source: output_SDE/rc_raphreal/n18_cMatrix.spi
* Map:      output_SDE/rc_raphreal/sram_schematic.txt
***********************************************************************
.OPTION POST=2 INGOLD=2 PROBE NOMOD METHOD=GEAR RUNLVL=5 MEASDGT=6
.TEMP 25

.HDL "../va/cfet_nmos_lvt.va"
.HDL "../va/cfet_pmos_lvt.va"

.PARAM VDD_VAL = 0.7
.PARAM TSTEP   = 1p
.PARAM DC_STEP = 1m
.PARAM LCH  = 16n
.PARAM WPG  = 25n
.PARAM WPD  = 25n
.PARAM WPU  = 25n
.PARAM NFPG = 1
.PARAM NFPD = 1
.PARAM NFPU = 1
.PARAM RBL_DRV   = 1e12
.PARAM RBLB_DRV  = 1e12
.PARAM RQ_FORCE  = 1e15
.PARAM RQB_FORCE = 1e15
.PARAM CBL_EXT   = 10f
.PARAM CBLB_EXT  = 10f
.PARAM CQ_EXT    = 1f
.PARAM CQB_EXT   = 1f

.SUBCKT SRAM_6T_STANDARD BL BLB WL Q QB VDD VSS
+ LCH=16n WPG=25n WPD=25n WPU=25n NFPG=1 NFPD=1 NFPU=1

* External ports to schematic-mapped RC nodes.
RPORT_BL   BL   BL_PORT   1m
RPORT_BLB  BLB  BLB_PORT  1m
RPORT_WL   WL   WL_PORT   1m
RPORT_Q    Q    Q_NODE    1m
RPORT_QB   QB   QB_NODE   1m
RPORT_VDD  VDD  VDD_PORT  1m
RPORT_VSS  VSS  VSS_PORT  1m

* SRAM devices. Terminals use names from sram_schematic.txt.
XPG1 PG1_BL_SD PG1_WL_GATE PG1_PD1_Q_SD VSS cfet_nmos_lvt
+ L='LCH' W='WPG' NF='NFPG'
XPG2 PG2_BLB_SD PG2_WL_GATE PD2_PG2_QB_SD VSS cfet_nmos_lvt
+ L='LCH' W='WPG' NF='NFPG'
XPD1 PG1_PD1_Q_SD PD1_QB_GATE PD1_VSS_SD VSS cfet_nmos_lvt
+ L='LCH' W='WPD' NF='NFPD'
XPD2 PD2_PG2_QB_SD PD2_Q_GATE PD2_VSS_SD VSS cfet_nmos_lvt
+ L='LCH' W='WPD' NF='NFPD'
XPU1 PU1_Q_SD PU1_QB_GATE PU1_VDD_SD VDD cfet_pmos_lvt
+ L='LCH' W='WPU' NF='NFPU'
XPU2 PU2_QB_SD PU2_Q_GATE PU2_VDD_SD VDD cfet_pmos_lvt
+ L='LCH' W='WPU' NF='NFPU'

* Resistance entries looked up through #define R names.
RMAP_ALIAS_PU2_Q_GATE_PD2_Q_GATE PU2_Q_GATE PD2_Q_GATE 1u $ same Q gate top/bottom in schematic map
RMAP_ALIAS_PU1_QB_GATE_PD1_QB_GATE PU1_QB_GATE PD1_QB_GATE 1u $ same QB gate top/bottom in schematic map
RMAP_BL_BL_PORT_PG1_BL_SD BL_PORT PG1_BL_SD 2.195710e+01 $ path R_35_53+R_53_67+R_64_67+R_11_64: Contact_M0_BL_1_5_Top <-> Contact_MD_L16_0_Bottom
RMAP_BLB_BLB_PORT_PG2_BLB_SD BLB_PORT PG2_BLB_SD 2.568020e+01 $ path R_42_59+R_59_60+R_2_60+R_2_31+R_31_47: Contact_M0_BLB_1_4_Top <-> Contact_MD_L16_4_Bottom
RMAP_WL_WL_PORT_PG1_WL_GATE WL_PORT PG1_WL_GATE 7.031990e+00 $ path R_33_51+R_51_68+R_63_68: Contact_M0_WL_1_0_Top <-> Contact_Gate_L7_0_Top
RMAP_WL_WL_PORT_PG2_WL_GATE WL_PORT PG2_WL_GATE 7.031990e+00 $ path R_33_51+R_51_58+R_20_58: Contact_M0_WL_1_0_Top <-> Contact_Gate_L7_3_Top
RMAP_WL_PG1_WL_GATE_PG2_WL_GATE PG1_WL_GATE PG2_WL_GATE 1.319760e+01 $ path R_63_68+R_51_68+R_51_58+R_20_58: Contact_Gate_L7_0_Top <-> Contact_Gate_L7_3_Top
RMAP_Q_Q_NODE_PG1_PD1_Q_SD Q_NODE PG1_PD1_Q_SD 5.248000e+01 $ direct R_21_22: Contact_MRW_Q_1_0_Top <-> Contact_MD_L16_1_Bottom
RMAP_Q_Q_NODE_PU1_Q_SD Q_NODE PU1_Q_SD 1.343127e+02 $ path R_0_22+R_0_43+R_27_43+R_5_27: Contact_MRW_Q_1_0_Top <-> Contact_BMD_L51_0_Top
RMAP_Q_Q_NODE_PD2_Q_GATE Q_NODE PD2_Q_GATE 8.509470e+01 $ path R_3_22+R_3_15+R_14_15+R_14_48+R_46_48+R_19_46: Contact_MRW_Q_1_0_Top <-> Contact_Gate_L7_2_Top
RMAP_Q_PG1_PD1_Q_SD_PU1_Q_SD PG1_PD1_Q_SD PU1_Q_SD 1.319730e+02 $ path R_0_21+R_0_43+R_27_43+R_5_27: Contact_MD_L16_1_Bottom <-> Contact_BMD_L51_0_Top
RMAP_Q_PG1_PD1_Q_SD_PD2_Q_GATE PG1_PD1_Q_SD PD2_Q_GATE 9.502260e+01 $ path R_0_21+R_0_22+R_3_22+R_3_15+R_14_15+R_14_48+R_46_48+R_19_46: Contact_MD_L16_1_Bottom <-> Contact_Gate_L7_2_Top
RMAP_Q_PU1_Q_SD_PD2_Q_GATE PU1_Q_SD PD2_Q_GATE 2.194074e+02 $ path R_5_27+R_27_43+R_0_43+R_0_22+R_3_22+R_3_15+R_14_15+R_14_48+R_46_48+R_19_46: Contact_BMD_L51_0_Top <-> Contact_Gate_L7_2_Top
RMAP_QB_QB_NODE_PD2_PG2_QB_SD QB_NODE PD2_PG2_QB_SD 5.902400e+11 $ path R_14_48+R_14_15+R_3_15+R_3_22+R_0_22+R_0_21+R_1_21+R_1_20+R_20_58+R_51_58+R_34_51+R_24_34+R_24_39: Contact_MRW_QB_1_1_Top <-> Contact_MD_L16_3_Bottom
RMAP_QB_QB_NODE_PU2_QB_SD QB_NODE PU2_QB_SD 5.902400e+11 $ path R_14_48+R_14_15+R_3_15+R_3_22+R_0_22+R_0_21+R_1_21+R_1_20+R_20_58+R_51_58+R_34_51+R_24_34+R_24_56+R_6_56+R_6_54+R_37_54: Contact_MRW_QB_1_1_Top <-> Contact_BMD_L51_3_Top
RMAP_QB_QB_NODE_PD1_QB_GATE QB_NODE PD1_QB_GATE 5.902400e+11 $ path R_14_48+R_14_15+R_3_15+R_3_22+R_0_22+R_0_21+R_1_21+R_1_20+R_20_58+R_51_58+R_34_51+R_26_34+R_25_26+R_9_25: Contact_MRW_QB_1_1_Top <-> Contact_Gate_L7_1_Top
RMAP_QB_PD2_PG2_QB_SD_PU2_QB_SD PD2_PG2_QB_SD PU2_QB_SD 1.323689e+02 $ path R_6_39+R_6_54+R_37_54: Contact_MD_L16_3_Bottom <-> Contact_BMD_L51_3_Top
RMAP_QB_PD2_PG2_QB_SD_PD1_QB_GATE PD2_PG2_QB_SD PD1_QB_GATE 5.638220e+01 $ path R_24_39+R_24_34+R_26_34+R_25_26+R_9_25: Contact_MD_L16_3_Bottom <-> Contact_Gate_L7_1_Top
RMAP_QB_PU2_QB_SD_PD1_QB_GATE PU2_QB_SD PD1_QB_GATE 1.772061e+02 $ path R_37_54+R_6_54+R_6_56+R_24_56+R_24_34+R_26_34+R_25_26+R_9_25: Contact_BMD_L51_3_Top <-> Contact_Gate_L7_1_Top
RMAP_VDD_VDD_PORT_PU1_VDD_SD VDD_PORT PU1_VDD_SD 3.850940e+01 $ path R_8_29+R_8_62+R_61_62+R_45_61: Contact_BM0_VDD_1_0_Bottom <-> Contact_BMD_L51_4_Top
RMAP_VDD_VDD_PORT_PU2_VDD_SD VDD_PORT PU2_VDD_SD 3.850940e+01 $ path R_8_29+R_8_62+R_61_62+R_45_61: Contact_BM0_VDD_1_0_Bottom <-> Contact_BMD_L51_4_Top
RMAP_VDD_PU1_VDD_SD_PU2_VDD_SD PU1_VDD_SD PU2_VDD_SD 1u $ same contact Contact_BMD_L51_4_Top
RMAP_VSS_VSS_PORT_PD2_VSS_SD VSS_PORT PD2_VSS_SD 4.056860e+01 $ path R_16_70+R_16_57+R_12_57+R_12_30: Contact_M0_VSS_1_3_Top <-> Contact_MD_L16_2_Bottom

* Capacitance entries looked up through #define C names.
CMAP_BL_PORT_BLB_PORT BL_PORT BLB_PORT 2.813200e-20 $ C_3_5: region_19 <-> region_21
CMAP_BL_PORT_WL_PORT BL_PORT WL_PORT 2.100100e-17 $ C_0_3: region_19 <-> region_16
CMAP_BL_PORT_VDD_PORT BL_PORT VDD_PORT 6.178700e-22 $ C_3_6: region_19 <-> region_22
CMAP_BL_PORT_VSS_PORT BL_PORT VSS_PORT 1.177000e-18 $ C_3_4: region_19 <-> region_20
CMAP_BL_PORT_Q_NODE BL_PORT Q_NODE 1.484100e-18 $ C_2_3: region_19 <-> region_18
CMAP_BL_PORT_QB_NODE BL_PORT QB_NODE 2.222800e-19 $ C_1_3: region_19 <-> region_17
CMAP_BLB_PORT_WL_PORT BLB_PORT WL_PORT 2.105800e-17 $ C_0_5: region_21 <-> region_16
CMAP_BLB_PORT_VDD_PORT BLB_PORT VDD_PORT 6.067700e-22 $ C_5_6: region_21 <-> region_22
CMAP_BLB_PORT_VSS_PORT BLB_PORT VSS_PORT 1.085400e-18 $ C_4_5: region_21 <-> region_20
CMAP_BLB_PORT_Q_NODE BLB_PORT Q_NODE 3.574200e-19 $ C_2_5: region_21 <-> region_18
CMAP_BLB_PORT_QB_NODE BLB_PORT QB_NODE 1.574900e-18 $ C_1_5: region_21 <-> region_17
CMAP_WL_PORT_VDD_PORT WL_PORT VDD_PORT 3.334300e-18 $ C_0_6: region_16 <-> region_22
CMAP_WL_PORT_VSS_PORT WL_PORT VSS_PORT 2.645700e-17 $ C_0_4: region_16 <-> region_20
CMAP_WL_PORT_Q_NODE WL_PORT Q_NODE 4.063800e-17 $ C_0_2: region_16 <-> region_18
CMAP_WL_PORT_QB_NODE WL_PORT QB_NODE 5.671100e-17 $ C_0_1: region_16 <-> region_17
CMAP_VDD_PORT_VSS_PORT VDD_PORT VSS_PORT 1.529300e-21 $ C_4_6: region_22 <-> region_20
CMAP_VDD_PORT_Q_NODE VDD_PORT Q_NODE 1.001500e-17 $ C_2_6: region_22 <-> region_18
CMAP_VDD_PORT_QB_NODE VDD_PORT QB_NODE 1.000800e-17 $ C_1_6: region_22 <-> region_17
CMAP_VSS_PORT_Q_NODE VSS_PORT Q_NODE 1.881400e-17 $ C_2_4: region_20 <-> region_18
CMAP_VSS_PORT_QB_NODE VSS_PORT QB_NODE 1.900100e-17 $ C_1_4: region_20 <-> region_17
CMAP_Q_NODE_QB_NODE Q_NODE QB_NODE 9.374700e-17 $ C_1_2: region_18 <-> region_17

.ENDS SRAM_6T_STANDARD

VDD_SRC  vdd 0 DC 'VDD_VAL'
VSS_SRC  vss 0 DC 0
VBL_DRV   bl_drv  0 DC 'VDD_VAL'
VBLB_DRV  blb_drv 0 DC 'VDD_VAL'
RBL_DRV   bl      bl_drv  'RBL_DRV'
RBLB_DRV  blb     blb_drv 'RBLB_DRV'
VWL_DRV wl 0 DC 0
VQF  q_force  0 DC 0
VQBF qb_force 0 DC 0
RQ_FORCE  q  q_force  'RQ_FORCE'
RQB_FORCE qb qb_force 'RQB_FORCE'
CBL_LOAD   bl  0 'CBL_EXT'
CBLB_LOAD  blb 0 'CBLB_EXT'
CQ_LOAD    q   0 'CQ_EXT'
CQB_LOAD   qb  0 'CQB_EXT'

XSRAM bl blb wl q qb vdd vss SRAM_6T_STANDARD
+ LCH='LCH' WPG='WPG' WPD='WPD' WPU='WPU'
+ NFPG='NFPG' NFPD='NFPD' NFPU='NFPU'

.PRINT TRAN V(bl) V(blb) V(wl) V(q) V(qb) I(VDD_SRC) I(VBL_DRV) I(VBLB_DRV)
.PRINT DC   V(q) V(qb) V(bl) V(blb) V(wl) I(VQF) I(VQBF) I(VDD_SRC) I(VBL_DRV) I(VBLB_DRV)

.NODESET V(q)='VDD_VAL' V(qb)=0 V(bl)='VDD_VAL' V(blb)='VDD_VAL'
.OP

.ALTER HOLD_SNM_Q_SWEEP
.PARAM RBL_DRV=1e15 RBLB_DRV=1e15 RQ_FORCE=1m RQB_FORCE=1e15
VBL_DRV  bl_drv  0 DC 'VDD_VAL'
VBLB_DRV blb_drv 0 DC 'VDD_VAL'
VWL_DRV  wl 0 DC 0
VQF      q_force 0 DC 0
VQBF     qb_force 0 DC 0
.NODESET V(qb)='VDD_VAL'
.DC VQF 0 'VDD_VAL' 'DC_STEP'

.ALTER HOLD_SNM_QB_SWEEP
.PARAM RBL_DRV=1e15 RBLB_DRV=1e15 RQ_FORCE=1e15 RQB_FORCE=1m
VBL_DRV  bl_drv  0 DC 'VDD_VAL'
VBLB_DRV blb_drv 0 DC 'VDD_VAL'
VWL_DRV  wl 0 DC 0
VQF      q_force 0 DC 0
VQBF     qb_force 0 DC 0
.NODESET V(q)='VDD_VAL'
.DC VQBF 0 'VDD_VAL' 'DC_STEP'

.ALTER READ_SNM_Q_SWEEP
.PARAM RBL_DRV=1m RBLB_DRV=1m RQ_FORCE=1m RQB_FORCE=1e15
VBL_DRV  bl_drv  0 DC 'VDD_VAL'
VBLB_DRV blb_drv 0 DC 'VDD_VAL'
VWL_DRV  wl 0 DC 'VDD_VAL'
VQF      q_force 0 DC 0
VQBF     qb_force 0 DC 0
.NODESET V(qb)='VDD_VAL'
.DC VQF 0 'VDD_VAL' 'DC_STEP'

.ALTER READ_SNM_QB_SWEEP
.PARAM RBL_DRV=1m RBLB_DRV=1m RQ_FORCE=1e15 RQB_FORCE=1m
VBL_DRV  bl_drv  0 DC 'VDD_VAL'
VBLB_DRV blb_drv 0 DC 'VDD_VAL'
VWL_DRV  wl 0 DC 'VDD_VAL'
VQF      q_force 0 DC 0
VQBF     qb_force 0 DC 0
.NODESET V(q)='VDD_VAL'
.DC VQBF 0 'VDD_VAL' 'DC_STEP'

.END
