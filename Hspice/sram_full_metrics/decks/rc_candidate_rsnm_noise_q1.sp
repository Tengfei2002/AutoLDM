* rc_candidate read noise-source RSNM q1
.OPTION POST=2 PROBE INGOLD=2 MEASDGT=6 METHOD=GEAR GSHUNT=1e-12
.TEMP 25
.INCLUDE "sram6t_rc_gate_direct.inc"
.PARAM VDD=0.7
VDD_SRC vdd 0 DC 'VDD'
VSS_SRC vss 0 DC 0

VNOISE vn 0 DC 0
VBL bl 0 DC 'VDD'
VBLB blb 0 DC 'VDD'
VWL wl 0 DC 'VDD'
EGQB gqb 0 VOL='V(qb)+V(vn)'
EGQ gq 0 VOL='V(q)-V(vn)'
CQ q 0 1f
CQB qb 0 1f
CBL bl 0 10f
CBLB blb 0 10f

XPG1 PG1_BL_SD PG1_WL_GATE PG1_PD1_Q_SD vss nmos_lvt L='LCH' W='WPG' NF='NF'
XPG2 PG2_BLB_SD PG2_WL_GATE PD2_PG2_QB_SD vss nmos_lvt L='LCH' W='WPG' NF='NF'
XPD1 PG1_PD1_Q_SD gqb PD1_VSS_SD vss nmos_lvt L='LCH' W='WPD' NF='NF'
XPD2 PD2_PG2_QB_SD gq PD2_VSS_SD vss nmos_lvt L='LCH' W='WPD' NF='NF'
XPU1 PU1_Q_SD gqb PU1_VDD_SD vdd pmos_lvt L='LCH' W='WPU' NF='NF'
XPU2 qb gq PU2_VDD_SD vdd pmos_lvt L='LCH' W='WPU' NF='NF'
RPORT_BL bl BL_PORT 1m
RPORT_BLB blb BLB_PORT 1m
RPORT_WL wl WL_PORT 1m
RPORT_Q q Q_NODE 1m
RPORT_QB qb QB_NODE 1m
RPORT_VDD vdd VDD_PORT 1m
RPORT_VSS vss VSS_PORT 1m
R_BL BL_PORT PG1_BL_SD 2.195710e1
R_BLB BLB_PORT PG2_BLB_SD 2.568020e1
R_WL1 WL_PORT PG1_WL_GATE 7.031990e0
R_WL2 WL_PORT PG2_WL_GATE 7.031990e0
R_Q_PD Q_NODE PG1_PD1_Q_SD 5.248000e1
R_Q_PU Q_NODE PU1_Q_SD 1.343127e2
R_QB_PD QB_NODE PD2_PG2_QB_SD 5.248000e1
R_QB_PU QB_NODE PU2_QB_SD 1.343127e2
R_VDD_PU1 VDD_PORT PU1_VDD_SD 3.850940e1
R_VDD_PU2 VDD_PORT PU2_VDD_SD 3.850940e1
R_VSS_PD1 VSS_PORT PD1_VSS_SD 4.056860e1
R_VSS_PD2 VSS_PORT PD2_VSS_SD 4.056860e1
C_BL_BLB BL_PORT BLB_PORT 2.813200e-20
C_BL_WL BL_PORT WL_PORT 2.100100e-17
C_BL_VDD BL_PORT VDD_PORT 6.178700e-22
C_BL_VSS BL_PORT VSS_PORT 1.177000e-18
C_BL_Q BL_PORT Q_NODE 1.484100e-18
C_BL_QB BL_PORT QB_NODE 2.222800e-19
C_BLB_WL BLB_PORT WL_PORT 2.105800e-17
C_BLB_VDD BLB_PORT VDD_PORT 6.067700e-22
C_BLB_VSS BLB_PORT VSS_PORT 1.085400e-18
C_BLB_Q BLB_PORT Q_NODE 3.574200e-19
C_BLB_QB BLB_PORT QB_NODE 1.574900e-18
C_WL_VDD WL_PORT VDD_PORT 3.334300e-18
C_WL_VSS WL_PORT VSS_PORT 2.645700e-17
C_WL_Q WL_PORT Q_NODE 4.063800e-17
C_WL_QB WL_PORT QB_NODE 5.671100e-17
C_VDD_VSS VDD_PORT VSS_PORT 1.529300e-21
C_VDD_Q VDD_PORT Q_NODE 1.001500e-17
C_VDD_QB VDD_PORT QB_NODE 1.000800e-17
C_VSS_Q VSS_PORT Q_NODE 1.881400e-17
C_VSS_QB VSS_PORT QB_NODE 1.900100e-17
C_Q_QB Q_NODE QB_NODE 9.374700e-17

.NODESET V(q)='VDD' V(qb)=0 V(bl)='VDD' V(blb)='VDD'
.DC VNOISE 0 0.5 0.001
.PRINT DC V(q) V(qb) V(gq) V(gqb) V(vn)
.END
