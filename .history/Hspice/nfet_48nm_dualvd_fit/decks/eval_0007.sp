***********************************************************************
* 48 nm NFET dual-Vd Id-Vg fitting deck: eval_0007
* Fixed: L=1.60000000e-08, W=2.50000000e-08, NF=1.0, EOT_0=7.90000000e-10
***********************************************************************
.OPTION POST=2 INGOLD=2 PROBE NOMOD
.TEMP 25

.HDL "../../va/cfet_nmos_lvt.va"

.PARAM LCH = 1.600000000000e-08
.PARAM WDEV = 2.500000000000e-08
.PARAM NFDEV = 1.000000000000e+00
.PARAM EOTFIX = 7.900000000000e-10

Vd d 0 DC 0
Vg g 0 DC 0
Vs s 0 DC 0
Vb b 0 DC 0

Xmn d g s b cfet_nmos_lvt
+ L='LCH' W='WDEV' NF='NFDEV'
+ U0=6.170460151387e-02 XL=1.011516663601e-08 DVTSHIFT=-6.886046026828e-01
+ DeltaWGAA=-1.165382409648e-08 DeltaTGAA=-4.904049415814e-10
+ EOT_0='EOTFIX'

.DC Vg POI 36 -0.116145 -0.104965 -0.0504956 -0.0181784 0.0203086 0.0419086 0.095925 0.107139 0.139721 0.177733 0.193737 0.204907 0.248438 0.291737 0.30294 0.400874 0.406691 0.504691 0.505099 0.603088 0.603563 0.707545 0.712468 0.800004 0.806075 0.903954 0.915554 1.00247 1.0086 1.10647 1.1126 1.205 1.20567 1.309 1.31515 1.40754 SWEEP Vd POI 2 0.05 0.70
.PRINT DC V(g) V(d) I(Vd) PAR('-I(Vd)')

.END
