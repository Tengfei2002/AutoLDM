* SPICE Models for Entire
* Capacitance Matrix (F)
R_0_1                      region_5   region_14    0.0000e+00
C_0_2                      region_5   region_23    1.2191e-20
C_0_3                      region_5   region_32    8.2282e-23
C_0_4                      region_5   region_6     1.2766e-21
C_0_5                      region_5   region_15    2.1571e-20
C_0_6                      region_5   region_24    1.6674e-19
C_0_7                      region_5   region_33    3.6453e-22
C_0_8                      region_5   region_7     2.9563e-21
C_0_9                      region_5   region_16    3.2848e-20
C_0_10                     region_5   region_25    5.4888e-20
C_0_11                     region_5   region_34    1.2783e-20
C_0_12                     region_5   region_8     1.3350e-19
C_0_13                     region_5   region_17    1.9150e-19
C_0_14                     region_5   region_26    5.8815e-22
C_0_15                     region_5   region_35    1.6468e-22
C_0_16                     region_5   region_9     4.9624e-18
C_0_17                     region_5   region_10    6.9975e-18
C_0_18                     region_5   region_18    5.8163e-18
C_0_19                     region_5   region_27    7.7492e-21
C_0_20                     region_5   region_36    1.2050e-20
C_0_21                     region_5   region_2     3.0827e-20
C_0_22                     region_5   region_11    6.5569e-20
C_0_23                     region_5   region_19    1.3899e-19
C_0_24                     region_5   region_20    2.1167e-18
C_0_25                     region_5   region_28    2.5632e-19
C_0_26                     region_5   region_37    1.1831e-20
C_0_27                     region_5   region_3     1.3978e-19
C_0_28                     region_5   region_12    1.0159e-21
C_0_29                     region_5   region_21    7.4459e-21
C_0_30                     region_5   region_29    3.1040e-20
C_0_31                     region_5   region_30    6.9298e-18
C_0_32                     region_5   region_38    5.4800e-23
C_0_33                     region_5   region_4     6.3124e-18
C_0_34                     region_5   region_13    4.4155e-22
C_0_35                     region_5   region_22    1.7391e-20
C_0_36                     region_5   region_31    2.6854e-20
C_0_37                     region_5   region_39    5.8169e-20
C_0_38                     region_5   region_40    4.3279e-20
C_1_2                      region_14  region_23    4.4592e-20
C_1_3                      region_14  region_32    1.2325e-23
C_1_4                      region_14  region_6     8.3469e-23
C_1_5                      region_14  region_15    4.0629e-23
C_1_6                      region_14  region_24    3.4590e-19
C_1_7                      region_14  region_33    2.8833e-22
C_1_8                      region_14  region_7     1.9643e-22
C_1_9                      region_14  region_16    3.7787e-23
C_1_10                     region_14  region_25    1.5528e-19
C_1_11                     region_14  region_34    2.4208e-20
C_1_12                     region_14  region_8     2.8930e-20
C_1_13                     region_14  region_17    1.5603e-22
C_1_14                     region_14  region_26    7.7206e-22
C_1_15                     region_14  region_35    1.7040e-22
C_1_16                     region_14  region_9     4.1748e-18
C_1_17                     region_14  region_10    4.5263e-18
C_1_18                     region_14  region_18    8.4203e-22
C_1_19                     region_14  region_27    3.7713e-22
C_1_20                     region_14  region_36    3.4262e-19
C_1_21                     region_14  region_2     4.4683e-22
C_1_22                     region_14  region_11    3.6261e-20
C_1_23                     region_14  region_19    3.3951e-22
C_1_24                     region_14  region_20    1.3623e-21
C_1_25                     region_14  region_28    1.5452e-20
C_1_26                     region_14  region_37    1.0604e-20
C_1_27                     region_14  region_3     2.8561e-21
C_1_28                     region_14  region_12    1.9501e-22
C_1_29                     region_14  region_21    3.0128e-20
C_1_30                     region_14  region_29    2.3678e-21
C_1_31                     region_14  region_30    5.4562e-19
C_1_32                     region_14  region_38    3.7257e-23
C_1_33                     region_14  region_4     6.6051e-20
C_1_34                     region_14  region_13    4.4664e-23
C_1_35                     region_14  region_22    2.9424e-20
R_1_36                     region_14  region_31    0.0000e+00
C_1_37                     region_14  region_39    3.8467e-19
C_1_38                     region_14  region_40    5.5896e-23
C_2_3                      region_23  region_32    2.1386e-20
C_2_4                      region_23  region_6     4.3918e-21
C_2_5                      region_23  region_15    1.4913e-23
C_2_6                      region_23  region_24    7.8366e-19
C_2_7                      region_23  region_33    1.5417e-19
C_2_8                      region_23  region_7     2.4851e-20
C_2_9                      region_23  region_16    9.1421e-24
C_2_10                     region_23  region_25    1.5412e-18
C_2_11                     region_23  region_34    7.8619e-19
C_2_12                     region_23  region_8     2.2976e-19
C_2_13                     region_23  region_17    2.2682e-23
C_2_14                     region_23  region_26    2.1047e-19
R_2_15                     region_23  region_35    0.0000e+00
C_2_16                     region_23  region_9     3.1756e-20
C_2_17                     region_23  region_10    3.7148e-20
C_2_18                     region_23  region_18    9.7128e-23
C_2_19                     region_23  region_27    5.8332e-21
R_2_20                     region_23  region_36    0.0000e+00
C_2_21                     region_23  region_2     1.3357e-21
C_2_22                     region_23  region_11    1.9212e-19
C_2_23                     region_23  region_19    8.5452e-24
C_2_24                     region_23  region_20    1.3448e-22
C_2_25                     region_23  region_28    3.0078e-20
C_2_26                     region_23  region_37    2.7988e-20
C_2_27                     region_23  region_3     3.5702e-22
C_2_28                     region_23  region_12    3.0280e-20
C_2_29                     region_23  region_21    1.8778e-17
C_2_30                     region_23  region_29    2.9958e-20
C_2_31                     region_23  region_30    1.0436e-19
C_2_32                     region_23  region_38    7.4837e-21
C_2_33                     region_23  region_4     6.5615e-22
C_2_34                     region_23  region_13    6.2549e-21
C_2_35                     region_23  region_22    1.3397e-17
C_2_36                     region_23  region_31    1.0599e-19
C_2_37                     region_23  region_39    6.5873e-20
C_2_38                     region_23  region_40    1.3999e-24
C_3_4                      region_32  region_6     4.7547e-19
C_3_5                      region_32  region_15    8.0996e-23
C_3_6                      region_32  region_24    1.0429e-18
C_3_7                      region_32  region_33    1.2522e-19
C_3_8                      region_32  region_7     5.7086e-19
C_3_9                      region_32  region_16    1.3159e-23
C_3_10                     region_32  region_25    1.9230e-22
C_3_11                     region_32  region_34    1.1548e-22
C_3_12                     region_32  region_8     1.1225e-20
C_3_13                     region_32  region_17    2.8419e-24
C_3_14                     region_32  region_26    4.9987e-19
C_3_15                     region_32  region_35    6.8146e-20
C_3_16                     region_32  region_9     6.5792e-23
C_3_17                     region_32  region_10    1.8668e-23
C_3_18                     region_32  region_18    4.9260e-24
C_3_19                     region_32  region_27    1.0316e-20
C_3_20                     region_32  region_36    2.7809e-23
C_3_21                     region_32  region_2     2.6391e-20
C_3_22                     region_32  region_11    2.2536e-22
C_3_23                     region_32  region_19    5.1851e-23
C_3_24                     region_32  region_20    1.6198e-22
C_3_25                     region_32  region_28    1.1981e-22
C_3_26                     region_32  region_37    9.0482e-21
C_3_27                     region_32  region_3     6.4302e-21
C_3_28                     region_32  region_12    3.7584e-20
R_3_29                     region_32  region_21    0.0000e+00
C_3_30                     region_32  region_29    9.3791e-22
C_3_31                     region_32  region_30    3.0479e-23
C_3_32                     region_32  region_38    6.1601e-19
C_3_33                     region_32  region_4     5.1003e-22
R_3_34                     region_32  region_13    0.0000e+00
C_3_35                     region_32  region_22    5.5738e-20
C_3_36                     region_32  region_31    6.7724e-24
C_3_37                     region_32  region_39    8.9503e-24
C_3_38                     region_32  region_40    8.4435e-24
C_4_5                      region_6   region_15    1.1274e-20
C_4_6                      region_6   region_24    8.0115e-19
C_4_7                      region_6   region_33    9.9804e-20
C_4_8                      region_6   region_7     1.4224e-19
C_4_9                      region_6   region_16    2.0595e-21
C_4_10                     region_6   region_25    1.7183e-21
C_4_11                     region_6   region_34    1.3728e-21
C_4_12                     region_6   region_8     2.8768e-20
C_4_13                     region_6   region_17    4.7105e-22
C_4_14                     region_6   region_26    3.0909e-19
C_4_15                     region_6   region_35    2.1785e-21
C_4_16                     region_6   region_9     3.0607e-22
C_4_17                     region_6   region_10    1.8377e-22
C_4_18                     region_6   region_18    3.3753e-22
C_4_19                     region_6   region_27    4.7340e-19
C_4_20                     region_6   region_36    5.9617e-23
C_4_21                     region_6   region_2     6.9932e-18
C_4_22                     region_6   region_11    2.1616e-22
C_4_23                     region_6   region_19    2.2933e-21
C_4_24                     region_6   region_20    2.1593e-20
C_4_25                     region_6   region_28    5.9835e-21
C_4_26                     region_6   region_37    6.5067e-21
C_4_27                     region_6   region_3     7.9592e-20
C_4_28                     region_6   region_12    1.4577e-20
C_4_29                     region_6   region_21    4.9729e-20
C_4_30                     region_6   region_29    4.6106e-20
C_4_31                     region_6   region_30    1.0928e-21
R_4_32                     region_6   region_38    0.0000e+00
C_4_33                     region_6   region_4     7.6836e-21
C_4_34                     region_6   region_13    4.5197e-18
C_4_35                     region_6   region_22    8.9023e-20
C_4_36                     region_6   region_31    1.9818e-23
C_4_37                     region_6   region_39    8.9954e-23
C_4_38                     region_6   region_40    4.9372e-22
C_5_6                      region_15  region_24    6.9650e-22
C_5_7                      region_15  region_33    3.1596e-22
C_5_8                      region_15  region_7     1.5497e-21
C_5_9                      region_15  region_16    3.0071e-18
C_5_10                     region_15  region_25    1.9185e-23
C_5_11                     region_15  region_34    2.3941e-23
C_5_12                     region_15  region_8     2.0525e-21
C_5_13                     region_15  region_17    7.2894e-20
C_5_14                     region_15  region_26    3.7727e-22
C_5_15                     region_15  region_35    9.3905e-24
C_5_16                     region_15  region_9     1.6561e-22
C_5_17                     region_15  region_10    3.4360e-22
C_5_18                     region_15  region_18    3.4897e-20
R_5_19                     region_15  region_27    0.0000e+00
C_5_20                     region_15  region_36    3.3126e-24
C_5_21                     region_15  region_2     5.8055e-18
C_5_22                     region_15  region_11    3.5888e-23
C_5_23                     region_15  region_19    1.8729e-19
C_5_24                     region_15  region_20    1.5694e-18
C_5_25                     region_15  region_28    3.3500e-20
C_5_26                     region_15  region_37    6.8769e-23
C_5_27                     region_15  region_3     3.7645e-18
C_5_28                     region_15  region_12    1.7276e-22
C_5_29                     region_15  region_21    3.8915e-23
C_5_30                     region_15  region_29    4.5129e-19
C_5_31                     region_15  region_30    9.8996e-21
C_5_32                     region_15  region_38    4.1785e-22
C_5_33                     region_15  region_4     2.2616e-20
C_5_34                     region_15  region_13    8.2137e-22
C_5_35                     region_15  region_22    2.8352e-22
C_5_36                     region_15  region_31    5.0644e-24
C_5_37                     region_15  region_39    1.4542e-23
C_5_38                     region_15  region_40    8.3705e-20
C_6_7                      region_24  region_33    2.1842e-20
C_6_8                      region_24  region_7     5.0607e-19
C_6_9                      region_24  region_16    1.2178e-22
C_6_10                     region_24  region_25    1.3457e-18
C_6_11                     region_24  region_34    1.9305e-20
C_6_12                     region_24  region_8     5.3846e-19
C_6_13                     region_24  region_17    1.1961e-22
C_6_14                     region_24  region_26    1.4882e-18
C_6_15                     region_24  region_35    7.4181e-20
C_6_16                     region_24  region_9     4.9207e-19
C_6_17                     region_24  region_10    7.1481e-19
C_6_18                     region_24  region_18    6.7424e-22
C_6_19                     region_24  region_27    9.2299e-21
C_6_20                     region_24  region_36    6.3808e-20
C_6_21                     region_24  region_2     1.7452e-19
C_6_22                     region_24  region_11    3.2899e-19
C_6_23                     region_24  region_19    1.0135e-21
C_6_24                     region_24  region_20    2.6015e-21
C_6_25                     region_24  region_28    4.4814e-21
R_6_26                     region_24  region_37    0.0000e+00
C_6_27                     region_24  region_3     7.9976e-20
C_6_28                     region_24  region_12    3.1572e-19
C_6_29                     region_24  region_21    2.7418e-17
C_6_30                     region_24  region_29    4.8188e-21
C_6_31                     region_24  region_30    1.6636e-20
C_6_32                     region_24  region_38    2.1845e-19
C_6_33                     region_24  region_4     7.8875e-20
C_6_34                     region_24  region_13    3.5620e-19
C_6_35                     region_24  region_22    8.3704e-19
C_6_36                     region_24  region_31    1.0143e-18
C_6_37                     region_24  region_39    1.8556e-19
C_6_38                     region_24  region_40    1.5882e-22
C_7_8                      region_33  region_7     1.3079e-18
C_7_9                      region_33  region_16    7.4924e-23
C_7_10                     region_33  region_25    3.9957e-21
C_7_11                     region_33  region_34    2.9547e-20
C_7_12                     region_33  region_8     1.6916e-20
C_7_13                     region_33  region_17    2.5659e-23
C_7_14                     region_33  region_26    2.8927e-19
C_7_15                     region_33  region_35    5.6959e-19
C_7_16                     region_33  region_9     8.1516e-23
C_7_17                     region_33  region_10    5.1141e-22
C_7_18                     region_33  region_18    1.7900e-23
R_7_19                     region_33  region_27    0.0000e+00
C_7_20                     region_33  region_36    6.3145e-22
C_7_21                     region_33  region_2     4.4667e-20
C_7_22                     region_33  region_11    1.4286e-21
C_7_23                     region_33  region_19    2.2079e-23
C_7_24                     region_33  region_20    4.0153e-22
C_7_25                     region_33  region_28    2.8235e-20
C_7_26                     region_33  region_37    6.5341e-22
C_7_27                     region_33  region_3     9.0182e-22
C_7_28                     region_33  region_12    5.3847e-20
C_7_29                     region_33  region_21    1.7788e-19
C_7_30                     region_33  region_29    4.2968e-19
C_7_31                     region_33  region_30    5.6324e-21
C_7_32                     region_33  region_38    1.3111e-19
C_7_33                     region_33  region_4     4.8430e-22
C_7_34                     region_33  region_13    2.7432e-19
R_7_35                     region_33  region_22    0.0000e+00
C_7_36                     region_33  region_31    4.7748e-23
C_7_37                     region_33  region_39    4.0723e-22
C_7_38                     region_33  region_40    3.3625e-24
C_8_9                      region_7   region_16    2.3967e-22
C_8_10                     region_7   region_25    9.1987e-23
C_8_11                     region_7   region_34    3.5988e-22
C_8_12                     region_7   region_8     2.1739e-19
C_8_13                     region_7   region_17    6.0034e-23
C_8_14                     region_7   region_26    3.2062e-20
C_8_15                     region_7   region_35    4.0498e-19
C_8_16                     region_7   region_9     1.3488e-21
C_8_17                     region_7   region_10    3.0717e-22
C_8_18                     region_7   region_18    1.6533e-22
R_8_19                     region_7   region_27    0.0000e+00
C_8_20                     region_7   region_36    1.1078e-22
C_8_21                     region_7   region_2     4.9620e-18
C_8_22                     region_7   region_11    1.5709e-21
C_8_23                     region_7   region_19    1.7550e-21
C_8_24                     region_7   region_20    2.3719e-21
C_8_25                     region_7   region_28    5.0907e-22
C_8_26                     region_7   region_37    6.7876e-20
C_8_27                     region_7   region_3     4.7649e-18
C_8_28                     region_7   region_12    4.3533e-18
C_8_29                     region_7   region_21    2.7295e-19
C_8_30                     region_7   region_29    3.7075e-19
C_8_31                     region_7   region_30    1.0306e-22
C_8_32                     region_7   region_38    2.4702e-20
C_8_33                     region_7   region_4     2.1162e-20
C_8_34                     region_7   region_13    4.2761e-18
C_8_35                     region_7   region_22    3.5121e-20
C_8_36                     region_7   region_31    6.3290e-23
C_8_37                     region_7   region_39    9.7213e-24
C_8_38                     region_7   region_40    2.3988e-22
C_9_10                     region_16  region_25    2.6759e-23
C_9_11                     region_16  region_34    2.1373e-23
C_9_12                     region_16  region_8     4.7697e-22
C_9_13                     region_16  region_17    2.6276e-19
C_9_14                     region_16  region_26    8.0722e-23
C_9_15                     region_16  region_35    2.9895e-24
C_9_16                     region_16  region_9     6.0795e-23
C_9_17                     region_16  region_10    4.7837e-22
C_9_18                     region_16  region_18    7.2703e-20
C_9_19                     region_16  region_27    1.2347e-19
C_9_20                     region_16  region_36    4.7086e-24
C_9_21                     region_16  region_2     1.8849e-19
C_9_22                     region_16  region_11    1.1414e-23
C_9_23                     region_16  region_19    2.1208e-18
C_9_24                     region_16  region_20    1.0633e-18
C_9_25                     region_16  region_28    1.2778e-19
C_9_26                     region_16  region_37    1.2861e-23
R_9_27                     region_16  region_3     0.0000e+00
C_9_28                     region_16  region_12    2.9727e-23
C_9_29                     region_16  region_21    9.1926e-24
C_9_30                     region_16  region_29    2.3571e-18
C_9_31                     region_16  region_30    2.3292e-20
C_9_32                     region_16  region_38    8.7948e-23
C_9_33                     region_16  region_4     2.9935e-20
C_9_34                     region_16  region_13    1.5073e-22
C_9_35                     region_16  region_22    8.2334e-23
C_9_36                     region_16  region_31    2.9991e-24
C_9_37                     region_16  region_39    2.4666e-23
C_9_38                     region_16  region_40    2.8475e-19
C_10_11                    region_25  region_34    7.6994e-20
C_10_12                    region_25  region_8     1.8331e-21
C_10_13                    region_25  region_17    9.4773e-23
C_10_14                    region_25  region_26    5.9692e-20
C_10_15                    region_25  region_35    5.5236e-22
C_10_16                    region_25  region_9     1.7299e-20
C_10_17                    region_25  region_10    3.5165e-19
C_10_18                    region_25  region_18    4.4057e-22
C_10_19                    region_25  region_27    2.1700e-21
C_10_20                    region_25  region_36    2.0543e-19
C_10_21                    region_25  region_2     5.0832e-22
C_10_22                    region_25  region_11    8.8410e-22
C_10_23                    region_25  region_19    3.6472e-23
C_10_24                    region_25  region_20    5.7820e-22
C_10_25                    region_25  region_28    2.5689e-20
C_10_26                    region_25  region_37    2.3261e-22
C_10_27                    region_25  region_3     1.8798e-22
C_10_28                    region_25  region_12    1.3598e-22
C_10_29                    region_25  region_21    4.0125e-18
C_10_30                    region_25  region_29    6.4151e-21
C_10_31                    region_25  region_30    1.9170e-19
C_10_32                    region_25  region_38    2.1543e-21
C_10_33                    region_25  region_4     1.0249e-21
C_10_34                    region_25  region_13    5.4836e-22
C_10_35                    region_25  region_22    5.6319e-19
C_10_36                    region_25  region_31    5.1159e-19
R_10_37                    region_25  region_39    0.0000e+00
C_10_38                    region_25  region_40    6.8703e-24
C_11_12                    region_34  region_8     2.6660e-19
C_11_13                    region_34  region_17    3.7930e-23
C_11_14                    region_34  region_26    4.9005e-21
C_11_15                    region_34  region_35    7.2983e-20
C_11_16                    region_34  region_9     5.9172e-20
C_11_17                    region_34  region_10    2.4256e-20
C_11_18                    region_34  region_18    1.1855e-22
C_11_19                    region_34  region_27    1.7486e-20
C_11_20                    region_34  region_36    5.7658e-19
C_11_21                    region_34  region_2     1.1130e-21
C_11_22                    region_34  region_11    1.3012e-18
C_11_23                    region_34  region_19    1.5063e-23
C_11_24                    region_34  region_20    1.5332e-22
R_11_25                    region_34  region_28    0.0000e+00
C_11_26                    region_34  region_37    5.8228e-21
C_11_27                    region_34  region_3     1.5495e-21
C_11_28                    region_34  region_12    1.2591e-20
C_11_29                    region_34  region_21    7.7277e-20
C_11_30                    region_34  region_29    1.6066e-19
C_11_31                    region_34  region_30    4.7239e-19
C_11_32                    region_34  region_38    8.5244e-22
C_11_33                    region_34  region_4     2.2214e-21
C_11_34                    region_34  region_13    6.8928e-22
R_11_35                    region_34  region_22    0.0000e+00
C_11_36                    region_34  region_31    5.1537e-21
C_11_37                    region_34  region_39    2.2583e-20
C_11_38                    region_34  region_40    1.4000e-24
C_12_13                    region_8   region_17    4.7886e-22
C_12_14                    region_8   region_26    1.3332e-21
C_12_15                    region_8   region_35    5.0096e-19
C_12_16                    region_8   region_9     2.2060e-19
C_12_17                    region_8   region_10    2.9074e-20
C_12_18                    region_8   region_18    2.0593e-21
C_12_19                    region_8   region_27    1.8469e-20
C_12_20                    region_8   region_36    3.7963e-20
C_12_21                    region_8   region_2     1.3346e-19
C_12_22                    region_8   region_11    4.7785e-18
C_12_23                    region_8   region_19    8.2112e-21
C_12_24                    region_8   region_20    4.3638e-21
C_12_25                    region_8   region_28    1.0079e-18
R_12_26                    region_8   region_37    0.0000e+00
C_12_27                    region_8   region_3     5.5479e-18
C_12_28                    region_8   region_12    4.6342e-18
C_12_29                    region_8   region_21    3.1165e-19
C_12_30                    region_8   region_29    1.0631e-18
C_12_31                    region_8   region_30    1.8710e-20
C_12_32                    region_8   region_38    8.3444e-22
C_12_33                    region_8   region_4     5.5479e-18
C_12_34                    region_8   region_13    2.8876e-20
C_12_35                    region_8   region_22    1.3223e-19
C_12_36                    region_8   region_31    1.1170e-20
C_12_37                    region_8   region_39    9.4153e-22
C_12_38                    region_8   region_40    8.8014e-22
C_13_14                    region_17  region_26    2.3218e-23
C_13_15                    region_17  region_35    1.9737e-24
C_13_16                    region_17  region_9     2.4290e-22
C_13_17                    region_17  region_10    2.1044e-21
C_13_18                    region_17  region_18    3.0098e-18
C_13_19                    region_17  region_27    2.3520e-20
C_13_20                    region_17  region_36    1.5636e-23
C_13_21                    region_17  region_2     3.2203e-20
C_13_22                    region_17  region_11    3.0050e-23
C_13_23                    region_17  region_19    2.1234e-18
C_13_24                    region_17  region_20    1.0623e-18
C_13_25                    region_17  region_28    2.3595e-18
C_13_26                    region_17  region_37    1.2948e-23
C_13_27                    region_17  region_3     3.0048e-20
C_13_28                    region_17  region_12    1.1389e-23
C_13_29                    region_17  region_21    9.7670e-24
C_13_30                    region_17  region_29    1.2935e-19
C_13_31                    region_17  region_30    1.2409e-19
C_13_32                    region_17  region_38    2.3822e-23
R_13_33                    region_17  region_4     0.0000e+00
C_13_34                    region_17  region_13    3.6656e-23
C_13_35                    region_17  region_22    6.3602e-23
C_13_36                    region_17  region_31    1.3891e-23
C_13_37                    region_17  region_39    9.2198e-23
C_13_38                    region_17  region_40    2.8480e-19
C_14_15                    region_26  region_35    1.5488e-20
C_14_16                    region_26  region_9     1.2749e-22
C_14_17                    region_26  region_10    2.1767e-21
C_14_18                    region_26  region_18    1.7362e-23
C_14_19                    region_26  region_27    1.0384e-19
C_14_20                    region_26  region_36    9.3766e-22
C_14_21                    region_26  region_2     4.6282e-20
C_14_22                    region_26  region_11    9.6558e-23
C_14_23                    region_26  region_19    2.8528e-23
C_14_24                    region_26  region_20    5.1013e-22
C_14_25                    region_26  region_28    3.6228e-21
C_14_26                    region_26  region_37    2.1958e-22
C_14_27                    region_26  region_3     6.7746e-22
C_14_28                    region_26  region_12    1.4193e-21
C_14_29                    region_26  region_21    4.0360e-18
C_14_30                    region_26  region_29    1.9762e-20
C_14_31                    region_26  region_30    3.0224e-21
R_14_32                    region_26  region_38    0.0000e+00
C_14_33                    region_26  region_4     1.3299e-22
C_14_34                    region_26  region_13    1.3959e-19
C_14_35                    region_26  region_22    1.6164e-18
C_14_36                    region_26  region_31    2.7031e-22
C_14_37                    region_26  region_39    2.4849e-21
C_14_38                    region_26  region_40    5.3628e-24
C_15_16                    region_35  region_9     1.6317e-21
C_15_17                    region_35  region_10    1.8656e-22
C_15_18                    region_35  region_18    2.8903e-24
C_15_19                    region_35  region_27    1.5207e-20
C_15_20                    region_35  region_36    7.6401e-21
C_15_21                    region_35  region_2     1.5171e-21
C_15_22                    region_35  region_11    3.6083e-20
C_15_23                    region_35  region_19    5.2996e-24
C_15_24                    region_35  region_20    1.4601e-23
C_15_25                    region_35  region_28    2.0311e-20
C_15_26                    region_35  region_37    4.6563e-20
C_15_27                    region_35  region_3     2.6042e-21
R_15_28                    region_35  region_12    0.0000e+00
C_15_29                    region_35  region_21    8.2409e-19
C_15_30                    region_35  region_29    2.7425e-19
C_15_31                    region_35  region_30    2.1894e-21
C_15_32                    region_35  region_38    5.1429e-21
C_15_33                    region_35  region_4     4.2461e-22
C_15_34                    region_35  region_13    2.1293e-20
C_15_35                    region_35  region_22    6.1750e-19
C_15_36                    region_35  region_31    2.7606e-22
C_15_37                    region_35  region_39    1.1707e-22
C_15_38                    region_35  region_40    6.3303e-25
C_16_17                    region_9   region_10    1.4223e-19
C_16_18                    region_9   region_18    1.5617e-21
C_16_19                    region_9   region_27    1.1609e-22
R_16_20                    region_9   region_36    0.0000e+00
C_16_21                    region_9   region_2     2.9551e-21
C_16_22                    region_9   region_11    4.3379e-18
C_16_23                    region_9   region_19    1.7561e-21
C_16_24                    region_9   region_20    2.3058e-21
C_16_25                    region_9   region_28    3.6243e-19
C_16_26                    region_9   region_37    6.7263e-20
C_16_27                    region_9   region_3     2.1159e-20
C_16_28                    region_9   region_12    1.4718e-21
C_16_29                    region_9   region_21    1.7058e-19
C_16_30                    region_9   region_29    7.1965e-22
R_16_31                    region_9   region_30    0.0000e+00
C_16_32                    region_9   region_38    1.0375e-23
C_16_33                    region_9   region_4     4.7645e-18
C_16_34                    region_9   region_13    1.9677e-22
C_16_35                    region_9   region_22    6.8557e-21
C_16_36                    region_9   region_31    4.2154e-19
C_16_37                    region_9   region_39    1.4935e-20
C_16_38                    region_9   region_40    2.4034e-22
C_17_18                    region_10  region_18    1.1428e-20
C_17_19                    region_10  region_27    1.0674e-21
C_17_20                    region_10  region_36    3.0928e-20
C_17_21                    region_10  region_2     1.2838e-21
C_17_22                    region_10  region_11    1.4871e-20
C_17_23                    region_10  region_19    2.3123e-21
C_17_24                    region_10  region_20    2.0882e-20
C_17_25                    region_10  region_28    4.5589e-20
C_17_26                    region_10  region_37    6.6236e-21
C_17_27                    region_10  region_3     7.7250e-21
C_17_28                    region_10  region_12    2.1692e-22
C_17_29                    region_10  region_21    5.9023e-20
C_17_30                    region_10  region_29    6.5692e-21
C_17_31                    region_10  region_30    5.0714e-19
C_17_32                    region_10  region_38    9.4331e-23
C_17_33                    region_10  region_4     8.0021e-20
C_17_34                    region_10  region_13    7.8182e-23
C_17_35                    region_10  region_22    4.5388e-20
C_17_36                    region_10  region_31    4.8225e-19
R_17_37                    region_10  region_39    0.0000e+00
C_17_38                    region_10  region_40    4.9976e-22
C_18_19                    region_18  region_27    9.9601e-21
C_18_20                    region_18  region_36    6.9946e-23
C_18_21                    region_18  region_2     2.1089e-20
C_18_22                    region_18  region_11    1.7431e-22
C_18_23                    region_18  region_19    1.8747e-19
C_18_24                    region_18  region_20    1.5567e-18
C_18_25                    region_18  region_28    4.5137e-19
C_18_26                    region_18  region_37    6.9217e-23
C_18_27                    region_18  region_3     2.2643e-20
C_18_28                    region_18  region_12    3.5824e-23
C_18_29                    region_18  region_21    4.2716e-23
C_18_30                    region_18  region_29    3.3890e-20
R_18_31                    region_18  region_30    0.0000e+00
C_18_32                    region_18  region_38    1.3896e-23
C_18_33                    region_18  region_4     3.7650e-18
C_18_34                    region_18  region_13    3.9845e-23
C_18_35                    region_18  region_22    1.6654e-22
C_18_36                    region_18  region_31    8.4734e-23
C_18_37                    region_18  region_39    4.3548e-22
C_18_38                    region_18  region_40    8.3793e-20
C_19_20                    region_27  region_36    4.4278e-22
C_19_21                    region_27  region_2     6.9122e-18
C_19_22                    region_27  region_11    1.0290e-21
C_19_23                    region_27  region_19    1.6287e-20
C_19_24                    region_27  region_20    1.7460e-19
C_19_25                    region_27  region_28    2.3255e-19
C_19_26                    region_27  region_37    8.8875e-23
C_19_27                    region_27  region_3     2.8222e-18
C_19_28                    region_27  region_12    1.5374e-19
C_19_29                    region_27  region_21    9.3778e-21
C_19_30                    region_27  region_29    1.1606e-17
C_19_31                    region_27  region_30    3.6203e-20
C_19_32                    region_27  region_38    9.0246e-20
C_19_33                    region_27  region_4     1.6258e-20
C_19_34                    region_27  region_13    4.7740e-19
C_19_35                    region_27  region_22    1.9306e-19
C_19_36                    region_27  region_31    3.8292e-23
C_19_37                    region_27  region_39    3.7697e-22
C_19_38                    region_27  region_40    1.6472e-21
C_20_21                    region_36  region_2     4.9681e-23
C_20_22                    region_36  region_11    3.9822e-19
C_20_23                    region_36  region_19    8.2849e-24
C_20_24                    region_36  region_20    8.8149e-23
C_20_25                    region_36  region_28    2.0492e-20
C_20_26                    region_36  region_37    1.0508e-20
C_20_27                    region_36  region_3     1.2250e-22
C_20_28                    region_36  region_12    1.4375e-21
C_20_29                    region_36  region_21    6.5291e-19
C_20_30                    region_36  region_29    3.2965e-21
C_20_31                    region_36  region_30    3.2002e-19
C_20_32                    region_36  region_38    5.0600e-23
C_20_33                    region_36  region_4     1.7677e-21
C_20_34                    region_36  region_13    3.1039e-23
C_20_35                    region_36  region_22    1.2430e-19
C_20_36                    region_36  region_31    5.7189e-19
C_20_37                    region_36  region_39    8.9139e-20
C_20_38                    region_36  region_40    1.2851e-24
C_21_22                    region_2   region_11    1.0225e-21
C_21_23                    region_2   region_19    1.3796e-19
C_21_24                    region_2   region_20    2.1787e-18
C_21_25                    region_2   region_28    3.0525e-20
C_21_26                    region_2   region_37    1.1816e-20
C_21_27                    region_2   region_3     6.3112e-18
C_21_28                    region_2   region_12    6.5408e-20
C_21_29                    region_2   region_21    6.7900e-21
C_21_30                    region_2   region_29    2.5668e-19
C_21_31                    region_2   region_30    7.6711e-21
C_21_32                    region_2   region_38    5.5994e-20
C_21_33                    region_2   region_4     1.3964e-19
R_21_34                    region_2   region_13    0.0000e+00
C_21_35                    region_2   region_22    3.1852e-20
C_21_36                    region_2   region_31    8.3342e-23
C_21_37                    region_2   region_39    5.8919e-23
C_21_38                    region_2   region_40    4.2898e-20
C_22_23                    region_11  region_19    2.8307e-22
C_22_24                    region_11  region_20    2.7193e-22
R_22_25                    region_11  region_28    0.0000e+00
C_22_26                    region_11  region_37    2.6891e-19
C_22_27                    region_11  region_3     3.7891e-20
C_22_28                    region_11  region_12    2.0886e-20
C_22_29                    region_11  region_21    3.0991e-19
C_22_30                    region_11  region_29    2.5185e-20
C_22_31                    region_11  region_30    1.6101e-19
C_22_32                    region_11  region_38    3.2934e-23
R_22_33                    region_11  region_4     0.0000e+00
C_22_34                    region_11  region_13    2.0179e-22
C_22_35                    region_11  region_22    2.5833e-20
C_22_36                    region_11  region_31    3.3350e-20
C_22_37                    region_11  region_39    6.0141e-22
C_22_38                    region_11  region_40    3.5117e-23
C_23_24                    region_19  region_20    9.7486e-19
C_23_25                    region_19  region_28    3.5722e-19
C_23_26                    region_19  region_37    1.8792e-22
C_23_27                    region_19  region_3     4.2944e-18
C_23_28                    region_19  region_12    2.8211e-22
C_23_29                    region_19  region_21    3.3449e-23
C_23_30                    region_19  region_29    3.5753e-19
C_23_31                    region_19  region_30    1.6291e-20
C_23_32                    region_19  region_38    3.3288e-23
C_23_33                    region_19  region_4     4.2940e-18
C_23_34                    region_19  region_13    3.3739e-22
C_23_35                    region_19  region_22    3.3847e-23
C_23_36                    region_19  region_31    5.3016e-23
C_23_37                    region_19  region_39    3.5885e-23
R_23_38                    region_19  region_40    0.0000e+00
C_24_25                    region_20  region_28    1.0560e-19
C_24_26                    region_20  region_37    1.8736e-22
C_24_27                    region_20  region_3     2.4155e-19
C_24_28                    region_20  region_12    2.7781e-22
C_24_29                    region_20  region_21    1.2007e-22
C_24_30                    region_20  region_29    1.0671e-19
C_24_31                    region_20  region_30    1.7101e-19
C_24_32                    region_20  region_38    5.7047e-22
C_24_33                    region_20  region_4     2.3970e-19
C_24_34                    region_20  region_13    1.3902e-21
C_24_35                    region_20  region_22    5.3164e-22
C_24_36                    region_20  region_31    1.6257e-22
C_24_37                    region_20  region_39    5.7434e-22
R_24_38                    region_20  region_40    0.0000e+00
C_25_26                    region_28  region_37    3.7593e-22
C_25_27                    region_28  region_3     6.7720e-19
C_25_28                    region_28  region_12    2.1346e-20
C_25_29                    region_28  region_21    5.7876e-21
C_25_30                    region_28  region_29    2.7072e-18
C_25_31                    region_28  region_30    1.1613e-17
C_25_32                    region_28  region_38    1.5149e-21
C_25_33                    region_28  region_4     1.5171e-17
C_25_34                    region_28  region_13    1.7692e-21
C_25_35                    region_28  region_22    2.0715e-19
C_25_36                    region_28  region_31    1.1129e-21
C_25_37                    region_28  region_39    1.2198e-20
C_25_38                    region_28  region_40    1.9914e-21
C_26_27                    region_37  region_3     2.5829e-20
C_26_28                    region_37  region_12    2.5769e-19
C_26_29                    region_37  region_21    2.6661e-19
C_26_30                    region_37  region_29    5.0857e-22
C_26_31                    region_37  region_30    9.4333e-23
C_26_32                    region_37  region_38    2.0278e-22
C_26_33                    region_37  region_4     2.5843e-20
C_26_34                    region_37  region_13    1.0706e-20
C_26_35                    region_37  region_22    2.4018e-21
C_26_36                    region_37  region_31    8.5567e-21
C_26_37                    region_37  region_39    2.1017e-22
C_26_38                    region_37  region_40    2.3470e-23
R_27_28                    region_3   region_12    0.0000e+00
C_27_29                    region_3   region_21    3.6628e-21
C_27_30                    region_3   region_29    1.5172e-17
C_27_31                    region_3   region_30    1.6355e-20
C_27_32                    region_3   region_38    8.4739e-22
C_27_33                    region_3   region_4     6.2726e-18
C_27_34                    region_3   region_13    6.6014e-20
C_27_35                    region_3   region_22    1.8788e-21
C_27_36                    region_3   region_31    5.1324e-22
C_27_37                    region_3   region_39    1.3306e-22
C_27_38                    region_3   region_40    1.0214e-19
C_28_29                    region_12  region_21    2.2297e-19
R_28_30                    region_12  region_29    0.0000e+00
C_28_31                    region_12  region_30    1.0842e-21
C_28_32                    region_12  region_38    8.2755e-22
C_28_33                    region_12  region_4     3.7851e-20
C_28_34                    region_12  region_13    3.7769e-20
C_28_35                    region_12  region_22    2.4367e-20
C_28_36                    region_12  region_31    1.7645e-22
C_28_37                    region_12  region_39    3.8434e-23
C_28_38                    region_12  region_40    3.4955e-23
C_29_30                    region_21  region_29    6.9598e-21
C_29_31                    region_21  region_30    1.4147e-20
C_29_32                    region_21  region_38    9.7825e-20
C_29_33                    region_21  region_4     3.7791e-21
C_29_34                    region_21  region_13    5.6223e-20
C_29_35                    region_21  region_22    1.5249e-18
R_29_36                    region_21  region_31    0.0000e+00
C_29_37                    region_21  region_39    9.2781e-20
C_29_38                    region_21  region_40    5.0236e-24
C_30_31                    region_29  region_30    2.4132e-19
C_30_32                    region_29  region_38    1.1286e-20
C_30_33                    region_29  region_4     6.7769e-19
C_30_34                    region_29  region_13    1.4229e-20
C_30_35                    region_29  region_22    4.7064e-19
C_30_36                    region_29  region_31    2.1801e-22
C_30_37                    region_29  region_39    2.1143e-21
C_30_38                    region_29  region_40    1.9979e-21
C_31_32                    region_30  region_38    3.6847e-22
C_31_33                    region_30  region_4     2.8225e-18
C_31_34                    region_30  region_13    3.3550e-22
C_31_35                    region_30  region_22    1.9136e-19
C_31_36                    region_30  region_31    1.6315e-20
C_31_37                    region_30  region_39    1.2383e-19
C_31_38                    region_30  region_40    1.6649e-21
C_32_33                    region_38  region_4     1.1640e-22
C_32_34                    region_38  region_13    3.8139e-19
C_32_35                    region_38  region_22    1.2542e-19
C_32_36                    region_38  region_31    1.0886e-23
C_32_37                    region_38  region_39    9.9107e-23
C_32_38                    region_38  region_40    6.4032e-24
C_33_34                    region_4   region_13    2.8456e-21
C_33_35                    region_4   region_22    1.7877e-21
C_33_36                    region_4   region_31    6.4153e-21
C_33_37                    region_4   region_39    9.6612e-22
C_33_38                    region_4   region_40    1.0215e-19
C_34_35                    region_13  region_22    6.6876e-20
C_34_36                    region_13  region_31    1.2340e-23
C_34_37                    region_13  region_39    3.1605e-23
C_34_38                    region_13  region_40    5.5353e-23
C_35_36                    region_22  region_31    6.5883e-21
C_35_37                    region_22  region_39    5.2653e-20
C_35_38                    region_22  region_40    4.6198e-24
C_36_37                    region_31  region_39    6.1956e-19
C_36_38                    region_31  region_40    8.7037e-24
C_37_38                    region_39  region_40    6.9369e-24
