* SPICE Models for Entire
* Capacitance Matrix (F)
C_0_1                      QB_b4   VDD_b1    1.5567e-18
C_0_2                      QB_b4   WL_b4     4.2717e-23
C_0_3                      QB_b4   BL_b1     1.7362e-23
C_0_4                      QB_b4   Q_b6      9.9602e-21
C_0_5                      QB_b4   BLB_b0    1.1428e-20
C_0_6                      QB_b4   QB_b5     9.7126e-23
C_0_7                      QB_b4   Q_b7      4.5137e-19
C_0_8                      QB_b4   WL_b5     8.4733e-23
C_0_9                      QB_b4   BL_b2     1.3896e-23
C_0_10                     QB_b4   VDD_b2    8.3793e-20
C_0_11                     QB_b4   Q_b0      3.7650e-18
C_0_12                     QB_b4   BLB_b1    4.4057e-22
C_0_13                     QB_b4   QB_b6     3.3890e-20
C_0_14                     QB_b4   WL_b6     4.9234e-24
C_0_15                     QB_b4   Q_b8      1.7901e-23
C_0_16                     QB_b4   Q_b1      1.6533e-22
R_0_17                     QB_b4   QB_b7     0.0000e+00
C_0_18                     QB_b4   Q_b9      1.1855e-22
C_0_19                     QB_b4   BLB_b2    4.3548e-22
C_0_20                     QB_b4   WL_b0     2.1089e-20
C_0_21                     QB_b4   QB_b0     2.2643e-20
C_0_22                     QB_b4   Q_b2      1.7430e-22
C_0_23                     QB_b4   QB_b8     2.8896e-24
C_0_24                     QB_b4   WL_b1     5.8163e-18
C_0_25                     QB_b4   VSS_b0    2.0593e-21
C_0_26                     QB_b4   QB_b1     1.5617e-21
C_0_27                     QB_b4   Q_b3      3.4897e-20
C_0_28                     QB_b4   QB_b9     6.9944e-23
C_0_29                     QB_b4   QB_b2     3.5822e-23
C_0_30                     QB_b4   WL_b2     3.9837e-23
C_0_31                     QB_b4   Q_b4      3.0098e-18
C_0_32                     QB_b4   VSS_b1    6.7424e-22
C_0_33                     QB_b4   BL_b0     3.3753e-22
C_0_34                     QB_b4   WL_b3     8.4202e-22
C_0_35                     QB_b4   QB_b3     7.2703e-20
C_0_36                     QB_b4   VDD_b0    1.8747e-19
C_0_37                     QB_b4   Q_b5      1.6654e-22
C_0_38                     QB_b4   VSS_b2    6.9216e-23
C_1_2                      VDD_b1  WL_b4     1.2003e-22
C_1_3                      VDD_b1  BL_b1     5.1012e-22
C_1_4                      VDD_b1  Q_b6      1.7459e-19
C_1_5                      VDD_b1  BLB_b0    2.0881e-20
C_1_6                      VDD_b1  QB_b5     1.3448e-22
C_1_7                      VDD_b1  Q_b7      1.0560e-19
C_1_8                      VDD_b1  WL_b5     1.6256e-22
C_1_9                      VDD_b1  BL_b2     5.7046e-22
R_1_10                     VDD_b1  VDD_b2    0.0000e+00
C_1_11                     VDD_b1  Q_b0      2.3970e-19
C_1_12                     VDD_b1  BLB_b1    5.7820e-22
C_1_13                     VDD_b1  QB_b6     1.0671e-19
C_1_14                     VDD_b1  WL_b6     1.6198e-22
C_1_15                     VDD_b1  Q_b8      4.0152e-22
C_1_16                     VDD_b1  Q_b1      2.3719e-21
C_1_17                     VDD_b1  QB_b7     1.7101e-19
C_1_18                     VDD_b1  Q_b9      1.5331e-22
C_1_19                     VDD_b1  BLB_b2    5.7434e-22
C_1_20                     VDD_b1  WL_b0     2.1787e-18
C_1_21                     VDD_b1  QB_b0     2.4155e-19
C_1_22                     VDD_b1  Q_b2      2.7191e-22
C_1_23                     VDD_b1  QB_b8     1.4605e-23
C_1_24                     VDD_b1  WL_b1     2.1167e-18
C_1_25                     VDD_b1  VSS_b0    4.3638e-21
C_1_26                     VDD_b1  QB_b1     2.3058e-21
C_1_27                     VDD_b1  Q_b3      1.5694e-18
C_1_28                     VDD_b1  QB_b9     8.8148e-23
C_1_29                     VDD_b1  QB_b2     2.7781e-22
C_1_30                     VDD_b1  WL_b2     1.3902e-21
C_1_31                     VDD_b1  Q_b4      1.0623e-18
C_1_32                     VDD_b1  VSS_b1    2.6015e-21
C_1_33                     VDD_b1  BL_b0     2.1593e-20
C_1_34                     VDD_b1  WL_b3     1.3623e-21
C_1_35                     VDD_b1  QB_b3     1.0633e-18
C_1_36                     VDD_b1  VDD_b0    9.7486e-19
C_1_37                     VDD_b1  Q_b5      5.3164e-22
C_1_38                     VDD_b1  VSS_b2    1.8736e-22
C_2_3                      WL_b4   BL_b1     4.0360e-18
C_2_4                      WL_b4   Q_b6      9.3778e-21
C_2_5                      WL_b4   BLB_b0    5.9023e-20
C_2_6                      WL_b4   QB_b5     1.8778e-17
C_2_7                      WL_b4   Q_b7      5.7876e-21
R_2_8                      WL_b4   WL_b5     0.0000e+00
C_2_9                      WL_b4   BL_b2     9.7825e-20
C_2_10                     WL_b4   VDD_b2    5.0224e-24
C_2_11                     WL_b4   Q_b0      3.7791e-21
C_2_12                     WL_b4   BLB_b1    4.0125e-18
C_2_13                     WL_b4   QB_b6     6.9598e-21
R_2_14                     WL_b4   WL_b6     0.0000e+00
C_2_15                     WL_b4   Q_b8      1.7788e-19
C_2_16                     WL_b4   Q_b1      2.7295e-19
C_2_17                     WL_b4   QB_b7     1.4147e-20
C_2_18                     WL_b4   Q_b9      7.7277e-20
C_2_19                     WL_b4   BLB_b2    9.2781e-20
C_2_20                     WL_b4   WL_b0     6.7900e-21
C_2_21                     WL_b4   QB_b0     3.6628e-21
C_2_22                     WL_b4   Q_b2      3.0991e-19
C_2_23                     WL_b4   QB_b8     8.2409e-19
C_2_24                     WL_b4   WL_b1     7.4458e-21
C_2_25                     WL_b4   VSS_b0    3.1165e-19
C_2_26                     WL_b4   QB_b1     1.7058e-19
C_2_27                     WL_b4   Q_b3      3.8919e-23
C_2_28                     WL_b4   QB_b9     6.5291e-19
C_2_29                     WL_b4   QB_b2     2.2297e-19
C_2_30                     WL_b4   WL_b2     5.6223e-20
C_2_31                     WL_b4   Q_b4      9.7699e-24
C_2_32                     WL_b4   VSS_b1    2.7418e-17
C_2_33                     WL_b4   BL_b0     4.9728e-20
C_2_34                     WL_b4   WL_b3     3.0128e-20
C_2_35                     WL_b4   QB_b3     9.1964e-24
C_2_36                     WL_b4   VDD_b0    3.3448e-23
C_2_37                     WL_b4   Q_b5      1.5249e-18
C_2_38                     WL_b4   VSS_b2    2.6661e-19
C_3_4                      BL_b1   Q_b6      1.0384e-19
C_3_5                      BL_b1   BLB_b0    2.1767e-21
C_3_6                      BL_b1   QB_b5     2.1047e-19
C_3_7                      BL_b1   Q_b7      3.6228e-21
C_3_8                      BL_b1   WL_b5     2.7031e-22
R_3_9                      BL_b1   BL_b2     0.0000e+00
C_3_10                     BL_b1   VDD_b2    5.3628e-24
C_3_11                     BL_b1   Q_b0      1.3298e-22
C_3_12                     BL_b1   BLB_b1    5.9692e-20
C_3_13                     BL_b1   QB_b6     1.9762e-20
C_3_14                     BL_b1   WL_b6     4.9987e-19
C_3_15                     BL_b1   Q_b8      2.8927e-19
C_3_16                     BL_b1   Q_b1      3.2062e-20
C_3_17                     BL_b1   QB_b7     3.0224e-21
C_3_18                     BL_b1   Q_b9      4.9005e-21
C_3_19                     BL_b1   BLB_b2    2.4849e-21
C_3_20                     BL_b1   WL_b0     4.6282e-20
C_3_21                     BL_b1   QB_b0     6.7745e-22
C_3_22                     BL_b1   Q_b2      9.6552e-23
C_3_23                     BL_b1   QB_b8     1.5488e-20
C_3_24                     BL_b1   WL_b1     5.8812e-22
C_3_25                     BL_b1   VSS_b0    1.3332e-21
C_3_26                     BL_b1   QB_b1     1.2748e-22
C_3_27                     BL_b1   Q_b3      3.7727e-22
C_3_28                     BL_b1   QB_b9     9.3766e-22
C_3_29                     BL_b1   QB_b2     1.4194e-21
C_3_30                     BL_b1   WL_b2     1.3959e-19
C_3_31                     BL_b1   Q_b4      2.3219e-23
C_3_32                     BL_b1   VSS_b1    1.4882e-18
C_3_33                     BL_b1   BL_b0     3.0909e-19
C_3_34                     BL_b1   WL_b3     7.7206e-22
C_3_35                     BL_b1   QB_b3     8.0721e-23
C_3_36                     BL_b1   VDD_b0    2.8528e-23
C_3_37                     BL_b1   Q_b5      1.6164e-18
C_3_38                     BL_b1   VSS_b2    2.1958e-22
C_4_5                      Q_b6    BLB_b0    1.0674e-21
C_4_6                      Q_b6    QB_b5     5.8332e-21
C_4_7                      Q_b6    Q_b7      2.3255e-19
C_4_8                      Q_b6    WL_b5     3.8296e-23
C_4_9                      Q_b6    BL_b2     9.0246e-20
C_4_10                     Q_b6    VDD_b2    1.6472e-21
C_4_11                     Q_b6    Q_b0      1.6258e-20
C_4_12                     Q_b6    BLB_b1    2.1700e-21
C_4_13                     Q_b6    QB_b6     1.1606e-17
C_4_14                     Q_b6    WL_b6     1.0316e-20
R_4_15                     Q_b6    Q_b8      0.0000e+00
R_4_16                     Q_b6    Q_b1      0.0000e+00
C_4_17                     Q_b6    QB_b7     3.6203e-20
C_4_18                     Q_b6    Q_b9      1.7486e-20
C_4_19                     Q_b6    BLB_b2    3.7696e-22
C_4_20                     Q_b6    WL_b0     6.9122e-18
C_4_21                     Q_b6    QB_b0     2.8222e-18
C_4_22                     Q_b6    Q_b2      1.0290e-21
C_4_23                     Q_b6    QB_b8     1.5207e-20
C_4_24                     Q_b6    WL_b1     7.7493e-21
C_4_25                     Q_b6    VSS_b0    1.8469e-20
C_4_26                     Q_b6    QB_b1     1.1610e-22
R_4_27                     Q_b6    Q_b3      0.0000e+00
C_4_28                     Q_b6    QB_b9     4.4278e-22
C_4_29                     Q_b6    QB_b2     1.5374e-19
C_4_30                     Q_b6    WL_b2     4.7740e-19
C_4_31                     Q_b6    Q_b4      2.3520e-20
C_4_32                     Q_b6    VSS_b1    9.2299e-21
C_4_33                     Q_b6    BL_b0     4.7340e-19
C_4_34                     Q_b6    WL_b3     3.7712e-22
C_4_35                     Q_b6    QB_b3     1.2347e-19
C_4_36                     Q_b6    VDD_b0    1.6287e-20
C_4_37                     Q_b6    Q_b5      1.9306e-19
C_4_38                     Q_b6    VSS_b2    8.8873e-23
C_5_6                      BLB_b0  QB_b5     3.7148e-20
C_5_7                      BLB_b0  Q_b7      4.5589e-20
C_5_8                      BLB_b0  WL_b5     4.8225e-19
C_5_9                      BLB_b0  BL_b2     9.4330e-23
C_5_10                     BLB_b0  VDD_b2    4.9976e-22
C_5_11                     BLB_b0  Q_b0      8.0021e-20
C_5_12                     BLB_b0  BLB_b1    3.5165e-19
C_5_13                     BLB_b0  QB_b6     6.5692e-21
C_5_14                     BLB_b0  WL_b6     1.8669e-23
C_5_15                     BLB_b0  Q_b8      5.1140e-22
C_5_16                     BLB_b0  Q_b1      3.0717e-22
C_5_17                     BLB_b0  QB_b7     5.0714e-19
C_5_18                     BLB_b0  Q_b9      2.4256e-20
R_5_19                     BLB_b0  BLB_b2    0.0000e+00
C_5_20                     BLB_b0  WL_b0     1.2838e-21
C_5_21                     BLB_b0  QB_b0     7.7250e-21
C_5_22                     BLB_b0  Q_b2      1.4871e-20
C_5_23                     BLB_b0  QB_b8     1.8656e-22
C_5_24                     BLB_b0  WL_b1     6.9975e-18
C_5_25                     BLB_b0  VSS_b0    2.9074e-20
C_5_26                     BLB_b0  QB_b1     1.4223e-19
C_5_27                     BLB_b0  Q_b3      3.4360e-22
C_5_28                     BLB_b0  QB_b9     3.0928e-20
C_5_29                     BLB_b0  QB_b2     2.1692e-22
C_5_30                     BLB_b0  WL_b2     7.8178e-23
C_5_31                     BLB_b0  Q_b4      2.1044e-21
C_5_32                     BLB_b0  VSS_b1    7.1481e-19
C_5_33                     BLB_b0  BL_b0     1.8377e-22
C_5_34                     BLB_b0  WL_b3     4.5263e-18
C_5_35                     BLB_b0  QB_b3     4.7838e-22
C_5_36                     BLB_b0  VDD_b0    2.3124e-21
C_5_37                     BLB_b0  Q_b5      4.5388e-20
C_5_38                     BLB_b0  VSS_b2    6.6236e-21
C_6_7                      QB_b5   Q_b7      3.0078e-20
C_6_8                      QB_b5   WL_b5     1.0599e-19
C_6_9                      QB_b5   BL_b2     7.4837e-21
C_6_10                     QB_b5   VDD_b2    1.3996e-24
C_6_11                     QB_b5   Q_b0      6.5616e-22
C_6_12                     QB_b5   BLB_b1    1.5412e-18
C_6_13                     QB_b5   QB_b6     2.9958e-20
C_6_14                     QB_b5   WL_b6     2.1386e-20
C_6_15                     QB_b5   Q_b8      1.5417e-19
C_6_16                     QB_b5   Q_b1      2.4851e-20
C_6_17                     QB_b5   QB_b7     1.0436e-19
C_6_18                     QB_b5   Q_b9      7.8619e-19
C_6_19                     QB_b5   BLB_b2    6.5873e-20
C_6_20                     QB_b5   WL_b0     1.3358e-21
C_6_21                     QB_b5   QB_b0     3.5702e-22
C_6_22                     QB_b5   Q_b2      1.9212e-19
R_6_23                     QB_b5   QB_b8     0.0000e+00
C_6_24                     QB_b5   WL_b1     1.2191e-20
C_6_25                     QB_b5   VSS_b0    2.2976e-19
C_6_26                     QB_b5   QB_b1     3.1756e-20
C_6_27                     QB_b5   Q_b3      1.4913e-23
R_6_28                     QB_b5   QB_b9     0.0000e+00
C_6_29                     QB_b5   QB_b2     3.0280e-20
C_6_30                     QB_b5   WL_b2     6.2549e-21
C_6_31                     QB_b5   Q_b4      2.2682e-23
C_6_32                     QB_b5   VSS_b1    7.8366e-19
C_6_33                     QB_b5   BL_b0     4.3918e-21
C_6_34                     QB_b5   WL_b3     4.4592e-20
C_6_35                     QB_b5   QB_b3     9.1421e-24
C_6_36                     QB_b5   VDD_b0    8.5451e-24
C_6_37                     QB_b5   Q_b5      1.3397e-17
C_6_38                     QB_b5   VSS_b2    2.7988e-20
C_7_8                      Q_b7    WL_b5     1.1129e-21
C_7_9                      Q_b7    BL_b2     1.5149e-21
C_7_10                     Q_b7    VDD_b2    1.9914e-21
C_7_11                     Q_b7    Q_b0      1.5171e-17
C_7_12                     Q_b7    BLB_b1    2.5689e-20
C_7_13                     Q_b7    QB_b6     2.7072e-18
C_7_14                     Q_b7    WL_b6     1.1982e-22
C_7_15                     Q_b7    Q_b8      2.8235e-20
C_7_16                     Q_b7    Q_b1      5.0907e-22
C_7_17                     Q_b7    QB_b7     1.1613e-17
R_7_18                     Q_b7    Q_b9      0.0000e+00
C_7_19                     Q_b7    BLB_b2    1.2198e-20
C_7_20                     Q_b7    WL_b0     3.0525e-20
C_7_21                     Q_b7    QB_b0     6.7720e-19
R_7_22                     Q_b7    Q_b2      0.0000e+00
C_7_23                     Q_b7    QB_b8     2.0311e-20
C_7_24                     Q_b7    WL_b1     2.5632e-19
C_7_25                     Q_b7    VSS_b0    1.0079e-18
C_7_26                     Q_b7    QB_b1     3.6243e-19
C_7_27                     Q_b7    Q_b3      3.3501e-20
C_7_28                     Q_b7    QB_b9     2.0492e-20
C_7_29                     Q_b7    QB_b2     2.1346e-20
C_7_30                     Q_b7    WL_b2     1.7692e-21
C_7_31                     Q_b7    Q_b4      2.3595e-18
C_7_32                     Q_b7    VSS_b1    4.4814e-21
C_7_33                     Q_b7    BL_b0     5.9835e-21
C_7_34                     Q_b7    WL_b3     1.5452e-20
C_7_35                     Q_b7    QB_b3     1.2778e-19
C_7_36                     Q_b7    VDD_b0    3.5722e-19
C_7_37                     Q_b7    Q_b5      2.0715e-19
C_7_38                     Q_b7    VSS_b2    3.7593e-22
C_8_9                      WL_b5   BL_b2     1.0886e-23
C_8_10                     WL_b5   VDD_b2    8.7037e-24
C_8_11                     WL_b5   Q_b0      6.4153e-21
C_8_12                     WL_b5   BLB_b1    5.1159e-19
C_8_13                     WL_b5   QB_b6     2.1802e-22
C_8_14                     WL_b5   WL_b6     6.7727e-24
C_8_15                     WL_b5   Q_b8      4.7748e-23
C_8_16                     WL_b5   Q_b1      6.3290e-23
C_8_17                     WL_b5   QB_b7     1.6315e-20
C_8_18                     WL_b5   Q_b9      5.1537e-21
C_8_19                     WL_b5   BLB_b2    6.1956e-19
C_8_20                     WL_b5   WL_b0     8.3358e-23
C_8_21                     WL_b5   QB_b0     5.1324e-22
C_8_22                     WL_b5   Q_b2      3.3350e-20
C_8_23                     WL_b5   QB_b8     2.7606e-22
C_8_24                     WL_b5   WL_b1     2.6854e-20
C_8_25                     WL_b5   VSS_b0    1.1170e-20
C_8_26                     WL_b5   QB_b1     4.2154e-19
C_8_27                     WL_b5   Q_b3      5.0638e-24
C_8_28                     WL_b5   QB_b9     5.7189e-19
C_8_29                     WL_b5   QB_b2     1.7645e-22
C_8_30                     WL_b5   WL_b2     1.2340e-23
C_8_31                     WL_b5   Q_b4      1.3891e-23
C_8_32                     WL_b5   VSS_b1    1.0143e-18
C_8_33                     WL_b5   BL_b0     1.9819e-23
R_8_34                     WL_b5   WL_b3     0.0000e+00
C_8_35                     WL_b5   QB_b3     2.9993e-24
C_8_36                     WL_b5   VDD_b0    5.3017e-23
C_8_37                     WL_b5   Q_b5      6.5883e-21
C_8_38                     WL_b5   VSS_b2    8.5567e-21
C_9_10                     BL_b2   VDD_b2    6.4030e-24
C_9_11                     BL_b2   Q_b0      1.1640e-22
C_9_12                     BL_b2   BLB_b1    2.1543e-21
C_9_13                     BL_b2   QB_b6     1.1286e-20
C_9_14                     BL_b2   WL_b6     6.1601e-19
C_9_15                     BL_b2   Q_b8      1.3111e-19
C_9_16                     BL_b2   Q_b1      2.4702e-20
C_9_17                     BL_b2   QB_b7     3.6847e-22
C_9_18                     BL_b2   Q_b9      8.5244e-22
C_9_19                     BL_b2   BLB_b2    9.9106e-23
C_9_20                     BL_b2   WL_b0     5.5994e-20
C_9_21                     BL_b2   QB_b0     8.4739e-22
C_9_22                     BL_b2   Q_b2      3.2934e-23
C_9_23                     BL_b2   QB_b8     5.1429e-21
C_9_24                     BL_b2   WL_b1     5.4796e-23
C_9_25                     BL_b2   VSS_b0    8.3444e-22
C_9_26                     BL_b2   QB_b1     1.0376e-23
C_9_27                     BL_b2   Q_b3      4.1785e-22
C_9_28                     BL_b2   QB_b9     5.0598e-23
C_9_29                     BL_b2   QB_b2     8.2755e-22
C_9_30                     BL_b2   WL_b2     3.8139e-19
C_9_31                     BL_b2   Q_b4      2.3822e-23
C_9_32                     BL_b2   VSS_b1    2.1845e-19
R_9_33                     BL_b2   BL_b0     0.0000e+00
C_9_34                     BL_b2   WL_b3     3.7255e-23
C_9_35                     BL_b2   QB_b3     8.7948e-23
C_9_36                     BL_b2   VDD_b0    3.3287e-23
C_9_37                     BL_b2   Q_b5      1.2542e-19
C_9_38                     BL_b2   VSS_b2    2.0278e-22
C_10_11                    VDD_b2  Q_b0      1.0215e-19
C_10_12                    VDD_b2  BLB_b1    6.8694e-24
C_10_13                    VDD_b2  QB_b6     1.9979e-21
C_10_14                    VDD_b2  WL_b6     8.4436e-24
C_10_15                    VDD_b2  Q_b8      3.3625e-24
C_10_16                    VDD_b2  Q_b1      2.3988e-22
C_10_17                    VDD_b2  QB_b7     1.6649e-21
C_10_18                    VDD_b2  Q_b9      1.3999e-24
C_10_19                    VDD_b2  BLB_b2    6.9368e-24
C_10_20                    VDD_b2  WL_b0     4.2898e-20
C_10_21                    VDD_b2  QB_b0     1.0214e-19
C_10_22                    VDD_b2  Q_b2      3.5116e-23
C_10_23                    VDD_b2  QB_b8     6.3312e-25
C_10_24                    VDD_b2  WL_b1     4.3279e-20
C_10_25                    VDD_b2  VSS_b0    8.8014e-22
C_10_26                    VDD_b2  QB_b1     2.4034e-22
C_10_27                    VDD_b2  Q_b3      8.3705e-20
C_10_28                    VDD_b2  QB_b9     1.2853e-24
C_10_29                    VDD_b2  QB_b2     3.4955e-23
C_10_30                    VDD_b2  WL_b2     5.5353e-23
C_10_31                    VDD_b2  Q_b4      2.8481e-19
C_10_32                    VDD_b2  VSS_b1    1.5882e-22
C_10_33                    VDD_b2  BL_b0     4.9372e-22
C_10_34                    VDD_b2  WL_b3     5.5896e-23
C_10_35                    VDD_b2  QB_b3     2.8475e-19
R_10_36                    VDD_b2  VDD_b0    0.0000e+00
C_10_37                    VDD_b2  Q_b5      4.6198e-24
C_10_38                    VDD_b2  VSS_b2    2.3470e-23
C_11_12                    Q_b0    BLB_b1    1.0249e-21
C_11_13                    Q_b0    QB_b6     6.7769e-19
C_11_14                    Q_b0    WL_b6     5.1003e-22
C_11_15                    Q_b0    Q_b8      4.8430e-22
C_11_16                    Q_b0    Q_b1      2.1162e-20
C_11_17                    Q_b0    QB_b7     2.8225e-18
C_11_18                    Q_b0    Q_b9      2.2214e-21
C_11_19                    Q_b0    BLB_b2    9.6613e-22
C_11_20                    Q_b0    WL_b0     1.3964e-19
C_11_21                    Q_b0    QB_b0     6.2726e-18
R_11_22                    Q_b0    Q_b2      0.0000e+00
C_11_23                    Q_b0    QB_b8     4.2460e-22
C_11_24                    Q_b0    WL_b1     6.3124e-18
C_11_25                    Q_b0    VSS_b0    5.5479e-18
C_11_26                    Q_b0    QB_b1     4.7645e-18
C_11_27                    Q_b0    Q_b3      2.2616e-20
C_11_28                    Q_b0    QB_b9     1.7677e-21
C_11_29                    Q_b0    QB_b2     3.7851e-20
C_11_30                    Q_b0    WL_b2     2.8456e-21
R_11_31                    Q_b0    Q_b4      0.0000e+00
C_11_32                    Q_b0    VSS_b1    7.8875e-20
C_11_33                    Q_b0    BL_b0     7.6836e-21
C_11_34                    Q_b0    WL_b3     6.6051e-20
C_11_35                    Q_b0    QB_b3     2.9935e-20
C_11_36                    Q_b0    VDD_b0    4.2940e-18
C_11_37                    Q_b0    Q_b5      1.7877e-21
C_11_38                    Q_b0    VSS_b2    2.5843e-20
C_12_13                    BLB_b1  QB_b6     6.4151e-21
C_12_14                    BLB_b1  WL_b6     1.9230e-22
C_12_15                    BLB_b1  Q_b8      3.9957e-21
C_12_16                    BLB_b1  Q_b1      9.1990e-23
C_12_17                    BLB_b1  QB_b7     1.9170e-19
C_12_18                    BLB_b1  Q_b9      7.6994e-20
R_12_19                    BLB_b1  BLB_b2    0.0000e+00
C_12_20                    BLB_b1  WL_b0     5.0836e-22
C_12_21                    BLB_b1  QB_b0     1.8796e-22
C_12_22                    BLB_b1  Q_b2      8.8410e-22
C_12_23                    BLB_b1  QB_b8     5.5236e-22
C_12_24                    BLB_b1  WL_b1     5.4888e-20
C_12_25                    BLB_b1  VSS_b0    1.8331e-21
C_12_26                    BLB_b1  QB_b1     1.7299e-20
C_12_27                    BLB_b1  Q_b3      1.9187e-23
C_12_28                    BLB_b1  QB_b9     2.0543e-19
C_12_29                    BLB_b1  QB_b2     1.3598e-22
C_12_30                    BLB_b1  WL_b2     5.4836e-22
C_12_31                    BLB_b1  Q_b4      9.4773e-23
C_12_32                    BLB_b1  VSS_b1    1.3457e-18
C_12_33                    BLB_b1  BL_b0     1.7183e-21
C_12_34                    BLB_b1  WL_b3     1.5528e-19
C_12_35                    BLB_b1  QB_b3     2.6761e-23
C_12_36                    BLB_b1  VDD_b0    3.6474e-23
C_12_37                    BLB_b1  Q_b5      5.6319e-19
C_12_38                    BLB_b1  VSS_b2    2.3261e-22
C_13_14                    QB_b6   WL_b6     9.3791e-22
C_13_15                    QB_b6   Q_b8      4.2968e-19
C_13_16                    QB_b6   Q_b1      3.7075e-19
C_13_17                    QB_b6   QB_b7     2.4132e-19
C_13_18                    QB_b6   Q_b9      1.6066e-19
C_13_19                    QB_b6   BLB_b2    2.1143e-21
C_13_20                    QB_b6   WL_b0     2.5668e-19
C_13_21                    QB_b6   QB_b0     1.5172e-17
C_13_22                    QB_b6   Q_b2      2.5185e-20
C_13_23                    QB_b6   QB_b8     2.7425e-19
C_13_24                    QB_b6   WL_b1     3.1040e-20
C_13_25                    QB_b6   VSS_b0    1.0631e-18
C_13_26                    QB_b6   QB_b1     7.1965e-22
C_13_27                    QB_b6   Q_b3      4.5129e-19
C_13_28                    QB_b6   QB_b9     3.2965e-21
R_13_29                    QB_b6   QB_b2     0.0000e+00
C_13_30                    QB_b6   WL_b2     1.4229e-20
C_13_31                    QB_b6   Q_b4      1.2935e-19
C_13_32                    QB_b6   VSS_b1    4.8188e-21
C_13_33                    QB_b6   BL_b0     4.6106e-20
C_13_34                    QB_b6   WL_b3     2.3678e-21
C_13_35                    QB_b6   QB_b3     2.3571e-18
C_13_36                    QB_b6   VDD_b0    3.5753e-19
C_13_37                    QB_b6   Q_b5      4.7064e-19
C_13_38                    QB_b6   VSS_b2    5.0856e-22
C_14_15                    WL_b6   Q_b8      1.2522e-19
C_14_16                    WL_b6   Q_b1      5.7086e-19
C_14_17                    WL_b6   QB_b7     3.0480e-23
C_14_18                    WL_b6   Q_b9      1.1548e-22
C_14_19                    WL_b6   BLB_b2    8.9512e-24
C_14_20                    WL_b6   WL_b0     2.6391e-20
C_14_21                    WL_b6   QB_b0     6.4302e-21
C_14_22                    WL_b6   Q_b2      2.2536e-22
C_14_23                    WL_b6   QB_b8     6.8146e-20
C_14_24                    WL_b6   WL_b1     8.2262e-23
C_14_25                    WL_b6   VSS_b0    1.1225e-20
C_14_26                    WL_b6   QB_b1     6.5791e-23
C_14_27                    WL_b6   Q_b3      8.0996e-23
C_14_28                    WL_b6   QB_b9     2.7809e-23
C_14_29                    WL_b6   QB_b2     3.7584e-20
R_14_30                    WL_b6   WL_b2     0.0000e+00
C_14_31                    WL_b6   Q_b4      2.8419e-24
C_14_32                    WL_b6   VSS_b1    1.0429e-18
C_14_33                    WL_b6   BL_b0     4.7547e-19
C_14_34                    WL_b6   WL_b3     1.2326e-23
C_14_35                    WL_b6   QB_b3     1.3160e-23
C_14_36                    WL_b6   VDD_b0    5.1851e-23
C_14_37                    WL_b6   Q_b5      5.5738e-20
C_14_38                    WL_b6   VSS_b2    9.0482e-21
C_15_16                    Q_b8    Q_b1      1.3079e-18
C_15_17                    Q_b8    QB_b7     5.6324e-21
C_15_18                    Q_b8    Q_b9      2.9547e-20
C_15_19                    Q_b8    BLB_b2    4.0723e-22
C_15_20                    Q_b8    WL_b0     4.4667e-20
C_15_21                    Q_b8    QB_b0     9.0182e-22
C_15_22                    Q_b8    Q_b2      1.4286e-21
C_15_23                    Q_b8    QB_b8     5.6959e-19
C_15_24                    Q_b8    WL_b1     3.6453e-22
C_15_25                    Q_b8    VSS_b0    1.6916e-20
C_15_26                    Q_b8    QB_b1     8.1516e-23
C_15_27                    Q_b8    Q_b3      3.1597e-22
C_15_28                    Q_b8    QB_b9     6.3145e-22
C_15_29                    Q_b8    QB_b2     5.3847e-20
C_15_30                    Q_b8    WL_b2     2.7432e-19
C_15_31                    Q_b8    Q_b4      2.5659e-23
C_15_32                    Q_b8    VSS_b1    2.1842e-20
C_15_33                    Q_b8    BL_b0     9.9804e-20
C_15_34                    Q_b8    WL_b3     2.8833e-22
C_15_35                    Q_b8    QB_b3     7.4924e-23
C_15_36                    Q_b8    VDD_b0    2.2079e-23
R_15_37                    Q_b8    Q_b5      0.0000e+00
C_15_38                    Q_b8    VSS_b2    6.5340e-22
C_16_17                    Q_b1    QB_b7     1.0306e-22
C_16_18                    Q_b1    Q_b9      3.5988e-22
C_16_19                    Q_b1    BLB_b2    9.7214e-24
C_16_20                    Q_b1    WL_b0     4.9620e-18
C_16_21                    Q_b1    QB_b0     4.7649e-18
C_16_22                    Q_b1    Q_b2      1.5709e-21
C_16_23                    Q_b1    QB_b8     4.0498e-19
C_16_24                    Q_b1    WL_b1     2.9563e-21
C_16_25                    Q_b1    VSS_b0    2.1739e-19
C_16_26                    Q_b1    QB_b1     1.3488e-21
C_16_27                    Q_b1    Q_b3      1.5497e-21
C_16_28                    Q_b1    QB_b9     1.1077e-22
C_16_29                    Q_b1    QB_b2     4.3533e-18
C_16_30                    Q_b1    WL_b2     4.2761e-18
C_16_31                    Q_b1    Q_b4      6.0036e-23
C_16_32                    Q_b1    VSS_b1    5.0607e-19
C_16_33                    Q_b1    BL_b0     1.4224e-19
C_16_34                    Q_b1    WL_b3     1.9643e-22
C_16_35                    Q_b1    QB_b3     2.3967e-22
C_16_36                    Q_b1    VDD_b0    1.7550e-21
C_16_37                    Q_b1    Q_b5      3.5121e-20
C_16_38                    Q_b1    VSS_b2    6.7876e-20
C_17_18                    QB_b7   Q_b9      4.7239e-19
C_17_19                    QB_b7   BLB_b2    1.2383e-19
C_17_20                    QB_b7   WL_b0     7.6711e-21
C_17_21                    QB_b7   QB_b0     1.6355e-20
C_17_22                    QB_b7   Q_b2      1.6101e-19
C_17_23                    QB_b7   QB_b8     2.1894e-21
C_17_24                    QB_b7   WL_b1     6.9298e-18
C_17_25                    QB_b7   VSS_b0    1.8710e-20
R_17_26                    QB_b7   QB_b1     0.0000e+00
C_17_27                    QB_b7   Q_b3      9.8996e-21
C_17_28                    QB_b7   QB_b9     3.2002e-19
C_17_29                    QB_b7   QB_b2     1.0842e-21
C_17_30                    QB_b7   WL_b2     3.3550e-22
C_17_31                    QB_b7   Q_b4      1.2409e-19
C_17_32                    QB_b7   VSS_b1    1.6636e-20
C_17_33                    QB_b7   BL_b0     1.0928e-21
C_17_34                    QB_b7   WL_b3     5.4562e-19
C_17_35                    QB_b7   QB_b3     2.3293e-20
C_17_36                    QB_b7   VDD_b0    1.6291e-20
C_17_37                    QB_b7   Q_b5      1.9136e-19
C_17_38                    QB_b7   VSS_b2    9.4329e-23
C_18_19                    Q_b9    BLB_b2    2.2583e-20
C_18_20                    Q_b9    WL_b0     1.1130e-21
C_18_21                    Q_b9    QB_b0     1.5495e-21
C_18_22                    Q_b9    Q_b2      1.3012e-18
C_18_23                    Q_b9    QB_b8     7.2983e-20
C_18_24                    Q_b9    WL_b1     1.2783e-20
C_18_25                    Q_b9    VSS_b0    2.6660e-19
C_18_26                    Q_b9    QB_b1     5.9172e-20
C_18_27                    Q_b9    Q_b3      2.3940e-23
C_18_28                    Q_b9    QB_b9     5.7658e-19
C_18_29                    Q_b9    QB_b2     1.2591e-20
C_18_30                    Q_b9    WL_b2     6.8928e-22
C_18_31                    Q_b9    Q_b4      3.7931e-23
C_18_32                    Q_b9    VSS_b1    1.9305e-20
C_18_33                    Q_b9    BL_b0     1.3728e-21
C_18_34                    Q_b9    WL_b3     2.4208e-20
C_18_35                    Q_b9    QB_b3     2.1372e-23
C_18_36                    Q_b9    VDD_b0    1.5063e-23
R_18_37                    Q_b9    Q_b5      0.0000e+00
C_18_38                    Q_b9    VSS_b2    5.8228e-21
C_19_20                    BLB_b2  WL_b0     5.8919e-23
C_19_21                    BLB_b2  QB_b0     1.3306e-22
C_19_22                    BLB_b2  Q_b2      6.0141e-22
C_19_23                    BLB_b2  QB_b8     1.1706e-22
C_19_24                    BLB_b2  WL_b1     5.8169e-20
C_19_25                    BLB_b2  VSS_b0    9.4153e-22
C_19_26                    BLB_b2  QB_b1     1.4935e-20
C_19_27                    BLB_b2  Q_b3      1.4543e-23
C_19_28                    BLB_b2  QB_b9     8.9139e-20
C_19_29                    BLB_b2  QB_b2     3.8434e-23
C_19_30                    BLB_b2  WL_b2     3.1605e-23
C_19_31                    BLB_b2  Q_b4      9.2198e-23
C_19_32                    BLB_b2  VSS_b1    1.8556e-19
C_19_33                    BLB_b2  BL_b0     8.9953e-23
C_19_34                    BLB_b2  WL_b3     3.8467e-19
C_19_35                    BLB_b2  QB_b3     2.4667e-23
C_19_36                    BLB_b2  VDD_b0    3.5884e-23
C_19_37                    BLB_b2  Q_b5      5.2653e-20
C_19_38                    BLB_b2  VSS_b2    2.1017e-22
C_20_21                    WL_b0   QB_b0     6.3112e-18
C_20_22                    WL_b0   Q_b2      1.0225e-21
C_20_23                    WL_b0   QB_b8     1.5171e-21
C_20_24                    WL_b0   WL_b1     3.0827e-20
C_20_25                    WL_b0   VSS_b0    1.3346e-19
C_20_26                    WL_b0   QB_b1     2.9551e-21
C_20_27                    WL_b0   Q_b3      5.8055e-18
C_20_28                    WL_b0   QB_b9     4.9668e-23
C_20_29                    WL_b0   QB_b2     6.5408e-20
R_20_30                    WL_b0   WL_b2     0.0000e+00
C_20_31                    WL_b0   Q_b4      3.2202e-20
C_20_32                    WL_b0   VSS_b1    1.7452e-19
C_20_33                    WL_b0   BL_b0     6.9932e-18
C_20_34                    WL_b0   WL_b3     4.4682e-22
C_20_35                    WL_b0   QB_b3     1.8849e-19
C_20_36                    WL_b0   VDD_b0    1.3796e-19
C_20_37                    WL_b0   Q_b5      3.1852e-20
C_20_38                    WL_b0   VSS_b2    1.1816e-20
C_21_22                    QB_b0   Q_b2      3.7891e-20
C_21_23                    QB_b0   QB_b8     2.6042e-21
C_21_24                    QB_b0   WL_b1     1.3978e-19
C_21_25                    QB_b0   VSS_b0    5.5479e-18
C_21_26                    QB_b0   QB_b1     2.1159e-20
C_21_27                    QB_b0   Q_b3      3.7645e-18
C_21_28                    QB_b0   QB_b9     1.2247e-22
R_21_29                    QB_b0   QB_b2     0.0000e+00
C_21_30                    QB_b0   WL_b2     6.6014e-20
C_21_31                    QB_b0   Q_b4      3.0048e-20
C_21_32                    QB_b0   VSS_b1    7.9976e-20
C_21_33                    QB_b0   BL_b0     7.9592e-20
C_21_34                    QB_b0   WL_b3     2.8561e-21
R_21_35                    QB_b0   QB_b3     0.0000e+00
C_21_36                    QB_b0   VDD_b0    4.2944e-18
C_21_37                    QB_b0   Q_b5      1.8788e-21
C_21_38                    QB_b0   VSS_b2    2.5829e-20
C_22_23                    Q_b2    QB_b8     3.6083e-20
C_22_24                    Q_b2    WL_b1     6.5569e-20
C_22_25                    Q_b2    VSS_b0    4.7785e-18
C_22_26                    Q_b2    QB_b1     4.3379e-18
C_22_27                    Q_b2    Q_b3      3.5888e-23
C_22_28                    Q_b2    QB_b9     3.9822e-19
C_22_29                    Q_b2    QB_b2     2.0886e-20
C_22_30                    Q_b2    WL_b2     2.0179e-22
C_22_31                    Q_b2    Q_b4      3.0049e-23
C_22_32                    Q_b2    VSS_b1    3.2899e-19
C_22_33                    Q_b2    BL_b0     2.1616e-22
C_22_34                    Q_b2    WL_b3     3.6261e-20
C_22_35                    Q_b2    QB_b3     1.1413e-23
C_22_36                    Q_b2    VDD_b0    2.8308e-22
C_22_37                    Q_b2    Q_b5      2.5833e-20
C_22_38                    Q_b2    VSS_b2    2.6891e-19
C_23_24                    QB_b8   WL_b1     1.6472e-22
C_23_25                    QB_b8   VSS_b0    5.0096e-19
C_23_26                    QB_b8   QB_b1     1.6317e-21
C_23_27                    QB_b8   Q_b3      9.3911e-24
C_23_28                    QB_b8   QB_b9     7.6401e-21
R_23_29                    QB_b8   QB_b2     0.0000e+00
C_23_30                    QB_b8   WL_b2     2.1293e-20
C_23_31                    QB_b8   Q_b4      1.9745e-24
C_23_32                    QB_b8   VSS_b1    7.4181e-20
C_23_33                    QB_b8   BL_b0     2.1785e-21
C_23_34                    QB_b8   WL_b3     1.7040e-22
C_23_35                    QB_b8   QB_b3     2.9901e-24
C_23_36                    QB_b8   VDD_b0    5.3032e-24
C_23_37                    QB_b8   Q_b5      6.1750e-19
C_23_38                    QB_b8   VSS_b2    4.6563e-20
C_24_25                    WL_b1   VSS_b0    1.3350e-19
C_24_26                    WL_b1   QB_b1     4.9624e-18
C_24_27                    WL_b1   Q_b3      2.1571e-20
C_24_28                    WL_b1   QB_b9     1.2050e-20
C_24_29                    WL_b1   QB_b2     1.0159e-21
C_24_30                    WL_b1   WL_b2     4.4153e-22
C_24_31                    WL_b1   Q_b4      1.9150e-19
C_24_32                    WL_b1   VSS_b1    1.6674e-19
C_24_33                    WL_b1   BL_b0     1.2766e-21
R_24_34                    WL_b1   WL_b3     0.0000e+00
C_24_35                    WL_b1   QB_b3     3.2849e-20
C_24_36                    WL_b1   VDD_b0    1.3899e-19
C_24_37                    WL_b1   Q_b5      1.7391e-20
C_24_38                    WL_b1   VSS_b2    1.1831e-20
C_25_26                    VSS_b0  QB_b1     2.2060e-19
C_25_27                    VSS_b0  Q_b3      2.0525e-21
C_25_28                    VSS_b0  QB_b9     3.7963e-20
C_25_29                    VSS_b0  QB_b2     4.6342e-18
C_25_30                    VSS_b0  WL_b2     2.8876e-20
C_25_31                    VSS_b0  Q_b4      4.7887e-22
C_25_32                    VSS_b0  VSS_b1    5.3846e-19
C_25_33                    VSS_b0  BL_b0     2.8768e-20
C_25_34                    VSS_b0  WL_b3     2.8930e-20
C_25_35                    VSS_b0  QB_b3     4.7697e-22
C_25_36                    VSS_b0  VDD_b0    8.2112e-21
C_25_37                    VSS_b0  Q_b5      1.3223e-19
R_25_38                    VSS_b0  VSS_b2    0.0000e+00
C_26_27                    QB_b1   Q_b3      1.6561e-22
R_26_28                    QB_b1   QB_b9     0.0000e+00
C_26_29                    QB_b1   QB_b2     1.4718e-21
C_26_30                    QB_b1   WL_b2     1.9677e-22
C_26_31                    QB_b1   Q_b4      2.4290e-22
C_26_32                    QB_b1   VSS_b1    4.9207e-19
C_26_33                    QB_b1   BL_b0     3.0607e-22
C_26_34                    QB_b1   WL_b3     4.1748e-18
C_26_35                    QB_b1   QB_b3     6.0797e-23
C_26_36                    QB_b1   VDD_b0    1.7561e-21
C_26_37                    QB_b1   Q_b5      6.8557e-21
C_26_38                    QB_b1   VSS_b2    6.7263e-20
C_27_28                    Q_b3    QB_b9     3.3067e-24
C_27_29                    Q_b3    QB_b2     1.7276e-22
C_27_30                    Q_b3    WL_b2     8.2137e-22
C_27_31                    Q_b3    Q_b4      7.2895e-20
C_27_32                    Q_b3    VSS_b1    6.9650e-22
C_27_33                    Q_b3    BL_b0     1.1274e-20
C_27_34                    Q_b3    WL_b3     4.0628e-23
C_27_35                    Q_b3    QB_b3     3.0071e-18
C_27_36                    Q_b3    VDD_b0    1.8729e-19
C_27_37                    Q_b3    Q_b5      2.8353e-22
C_27_38                    Q_b3    VSS_b2    6.8769e-23
C_28_29                    QB_b9   QB_b2     1.4375e-21
C_28_30                    QB_b9   WL_b2     3.1037e-23
C_28_31                    QB_b9   Q_b4      1.5634e-23
C_28_32                    QB_b9   VSS_b1    6.3808e-20
C_28_33                    QB_b9   BL_b0     5.9611e-23
C_28_34                    QB_b9   WL_b3     3.4262e-19
C_28_35                    QB_b9   QB_b3     4.7078e-24
C_28_36                    QB_b9   VDD_b0    8.2830e-24
C_28_37                    QB_b9   Q_b5      1.2430e-19
C_28_38                    QB_b9   VSS_b2    1.0508e-20
C_29_30                    QB_b2   WL_b2     3.7769e-20
C_29_31                    QB_b2   Q_b4      1.1388e-23
C_29_32                    QB_b2   VSS_b1    3.1572e-19
C_29_33                    QB_b2   BL_b0     1.4577e-20
C_29_34                    QB_b2   WL_b3     1.9501e-22
C_29_35                    QB_b2   QB_b3     2.9726e-23
C_29_36                    QB_b2   VDD_b0    2.8211e-22
C_29_37                    QB_b2   Q_b5      2.4367e-20
C_29_38                    QB_b2   VSS_b2    2.5769e-19
C_30_31                    WL_b2   Q_b4      3.6659e-23
C_30_32                    WL_b2   VSS_b1    3.5620e-19
C_30_33                    WL_b2   BL_b0     4.5197e-18
C_30_34                    WL_b2   WL_b3     4.4666e-23
C_30_35                    WL_b2   QB_b3     1.5072e-22
C_30_36                    WL_b2   VDD_b0    3.3739e-22
C_30_37                    WL_b2   Q_b5      6.6876e-20
C_30_38                    WL_b2   VSS_b2    1.0706e-20
C_31_32                    Q_b4    VSS_b1    1.1961e-22
C_31_33                    Q_b4    BL_b0     4.7105e-22
C_31_34                    Q_b4    WL_b3     1.5603e-22
C_31_35                    Q_b4    QB_b3     2.6276e-19
C_31_36                    Q_b4    VDD_b0    2.1234e-18
C_31_37                    Q_b4    Q_b5      6.3602e-23
C_31_38                    Q_b4    VSS_b2    1.2948e-23
C_32_33                    VSS_b1  BL_b0     8.0115e-19
C_32_34                    VSS_b1  WL_b3     3.4590e-19
C_32_35                    VSS_b1  QB_b3     1.2178e-22
C_32_36                    VSS_b1  VDD_b0    1.0135e-21
C_32_37                    VSS_b1  Q_b5      8.3704e-19
R_32_38                    VSS_b1  VSS_b2    0.0000e+00
C_33_34                    BL_b0   WL_b3     8.3466e-23
C_33_35                    BL_b0   QB_b3     2.0595e-21
C_33_36                    BL_b0   VDD_b0    2.2933e-21
C_33_37                    BL_b0   Q_b5      8.9023e-20
C_33_38                    BL_b0   VSS_b2    6.5067e-21
C_34_35                    WL_b3   QB_b3     3.7787e-23
C_34_36                    WL_b3   VDD_b0    3.3951e-22
C_34_37                    WL_b3   Q_b5      2.9424e-20
C_34_38                    WL_b3   VSS_b2    1.0604e-20
C_35_36                    QB_b3   VDD_b0    2.1208e-18
C_35_37                    QB_b3   Q_b5      8.2334e-23
C_35_38                    QB_b3   VSS_b2    1.2860e-23
C_36_37                    VDD_b0  Q_b5      3.3847e-23
C_36_38                    VDD_b0  VSS_b2    1.8792e-22
C_37_38                    Q_b5    VSS_b2    2.4018e-21
